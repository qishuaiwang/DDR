#
# ABSTRACT : RAL file generated for dwc_ddrphy_top
#
block dwc_ddrphy_top_DWC_DDRPHYA_ACSM0 {
  endian little;
  bytes 2;
  register AcsmSeq0x0 @'h0 {
    field RFU_AcsmSeq0x0 @0 {
       bits 16;
       access rw;
       reset 16'h0;
    }
  }
  register AcsmSeq0x1 @'h1 {
    field RFU_AcsmSeq0x1 @0 {
       bits 16;
       access rw;
       reset 16'h0;
    }
  }
  register AcsmSeq0x2 @'h2 {
    field RFU_AcsmSeq0x2 @0 {
       bits 16;
       access rw;
       reset 16'h0;
    }
  }
  register AcsmSeq0x3 @'h3 {
    field RFU_AcsmSeq0x3 @0 {
       bits 16;
       access rw;
       reset 16'h0;
    }
  }
  register AcsmSeq0x4 @'h4 {
    field RFU_AcsmSeq0x4 @0 {
       bits 16;
       access rw;
       reset 16'h0;
    }
  }
  register AcsmSeq0x5 @'h5 {
    field RFU_AcsmSeq0x5 @0 {
       bits 16;
       access rw;
       reset 16'h0;
    }
  }
  register AcsmSeq0x6 @'h6 {
    field RFU_AcsmSeq0x6 @0 {
       bits 16;
       access rw;
       reset 16'h0;
    }
  }
  register AcsmSeq0x7 @'h7 {
    field RFU_AcsmSeq0x7 @0 {
       bits 16;
       access rw;
       reset 16'h0;
    }
  }
  register AcsmSeq0x8 @'h8 {
    field RFU_AcsmSeq0x8 @0 {
       bits 16;
       access rw;
       reset 16'h0;
    }
  }
  register AcsmSeq0x9 @'h9 {
    field RFU_AcsmSeq0x9 @0 {
       bits 16;
       access rw;
       reset 16'h0;
    }
  }
  register AcsmSeq0x10 @'ha {
    field RFU_AcsmSeq0x10 @0 {
       bits 16;
       access rw;
       reset 16'h0;
    }
  }
  register AcsmSeq0x11 @'hb {
    field RFU_AcsmSeq0x11 @0 {
       bits 16;
       access rw;
       reset 16'h0;
    }
  }
  register AcsmSeq0x12 @'hc {
    field RFU_AcsmSeq0x12 @0 {
       bits 16;
       access rw;
       reset 16'h0;
    }
  }
  register AcsmSeq0x13 @'hd {
    field RFU_AcsmSeq0x13 @0 {
       bits 16;
       access rw;
       reset 16'h0;
    }
  }
  register AcsmSeq0x14 @'he {
    field RFU_AcsmSeq0x14 @0 {
       bits 16;
       access rw;
       reset 16'h0;
    }
  }
  register AcsmSeq0x15 @'hf {
    field RFU_AcsmSeq0x15 @0 {
       bits 16;
       access rw;
       reset 16'h0;
    }
  }
  register AcsmSeq0x16 @'h10 {
    field RFU_AcsmSeq0x16 @0 {
       bits 16;
       access rw;
       reset 16'h0;
    }
  }
  register AcsmSeq0x17 @'h11 {
    field RFU_AcsmSeq0x17 @0 {
       bits 16;
       access rw;
       reset 16'h0;
    }
  }
  register AcsmSeq0x18 @'h12 {
    field RFU_AcsmSeq0x18 @0 {
       bits 16;
       access rw;
       reset 16'h0;
    }
  }
  register AcsmSeq0x19 @'h13 {
    field RFU_AcsmSeq0x19 @0 {
       bits 16;
       access rw;
       reset 16'h0;
    }
  }
  register AcsmSeq0x20 @'h14 {
    field RFU_AcsmSeq0x20 @0 {
       bits 16;
       access rw;
       reset 16'h0;
    }
  }
  register AcsmSeq0x21 @'h15 {
    field RFU_AcsmSeq0x21 @0 {
       bits 16;
       access rw;
       reset 16'h0;
    }
  }
  register AcsmSeq0x22 @'h16 {
    field RFU_AcsmSeq0x22 @0 {
       bits 16;
       access rw;
       reset 16'h0;
    }
  }
  register AcsmSeq0x23 @'h17 {
    field RFU_AcsmSeq0x23 @0 {
       bits 16;
       access rw;
       reset 16'h0;
    }
  }
  register AcsmSeq0x24 @'h18 {
    field RFU_AcsmSeq0x24 @0 {
       bits 16;
       access rw;
       reset 16'h0;
    }
  }
  register AcsmSeq0x25 @'h19 {
    field RFU_AcsmSeq0x25 @0 {
       bits 16;
       access rw;
       reset 16'h0;
    }
  }
  register AcsmSeq0x26 @'h1a {
    field RFU_AcsmSeq0x26 @0 {
       bits 16;
       access rw;
       reset 16'h0;
    }
  }
  register AcsmSeq0x27 @'h1b {
    field RFU_AcsmSeq0x27 @0 {
       bits 16;
       access rw;
       reset 16'h0;
    }
  }
  register AcsmSeq0x28 @'h1c {
    field RFU_AcsmSeq0x28 @0 {
       bits 16;
       access rw;
       reset 16'h0;
    }
  }
  register AcsmSeq0x29 @'h1d {
    field RFU_AcsmSeq0x29 @0 {
       bits 16;
       access rw;
       reset 16'h0;
    }
  }
  register AcsmSeq0x30 @'h1e {
    field RFU_AcsmSeq0x30 @0 {
       bits 16;
       access rw;
       reset 16'h0;
    }
  }
  register AcsmSeq0x31 @'h1f {
    field RFU_AcsmSeq0x31 @0 {
       bits 16;
       access rw;
       reset 16'h0;
    }
  }
  register AcsmSeq1x0 @'h20 {
    field RFU_AcsmSeq1x0 @0 {
       bits 16;
       access rw;
       reset 16'h0;
    }
  }
  register AcsmSeq1x1 @'h21 {
    field RFU_AcsmSeq1x1 @0 {
       bits 16;
       access rw;
       reset 16'h0;
    }
  }
  register AcsmSeq1x2 @'h22 {
    field RFU_AcsmSeq1x2 @0 {
       bits 16;
       access rw;
       reset 16'h0;
    }
  }
  register AcsmSeq1x3 @'h23 {
    field RFU_AcsmSeq1x3 @0 {
       bits 16;
       access rw;
       reset 16'h0;
    }
  }
  register AcsmSeq1x4 @'h24 {
    field RFU_AcsmSeq1x4 @0 {
       bits 16;
       access rw;
       reset 16'h0;
    }
  }
  register AcsmSeq1x5 @'h25 {
    field RFU_AcsmSeq1x5 @0 {
       bits 16;
       access rw;
       reset 16'h0;
    }
  }
  register AcsmSeq1x6 @'h26 {
    field RFU_AcsmSeq1x6 @0 {
       bits 16;
       access rw;
       reset 16'h0;
    }
  }
  register AcsmSeq1x7 @'h27 {
    field RFU_AcsmSeq1x7 @0 {
       bits 16;
       access rw;
       reset 16'h0;
    }
  }
  register AcsmSeq1x8 @'h28 {
    field RFU_AcsmSeq1x8 @0 {
       bits 16;
       access rw;
       reset 16'h0;
    }
  }
  register AcsmSeq1x9 @'h29 {
    field RFU_AcsmSeq1x9 @0 {
       bits 16;
       access rw;
       reset 16'h0;
    }
  }
  register AcsmSeq1x10 @'h2a {
    field RFU_AcsmSeq1x10 @0 {
       bits 16;
       access rw;
       reset 16'h0;
    }
  }
  register AcsmSeq1x11 @'h2b {
    field RFU_AcsmSeq1x11 @0 {
       bits 16;
       access rw;
       reset 16'h0;
    }
  }
  register AcsmSeq1x12 @'h2c {
    field RFU_AcsmSeq1x12 @0 {
       bits 16;
       access rw;
       reset 16'h0;
    }
  }
  register AcsmSeq1x13 @'h2d {
    field RFU_AcsmSeq1x13 @0 {
       bits 16;
       access rw;
       reset 16'h0;
    }
  }
  register AcsmSeq1x14 @'h2e {
    field RFU_AcsmSeq1x14 @0 {
       bits 16;
       access rw;
       reset 16'h0;
    }
  }
  register AcsmSeq1x15 @'h2f {
    field RFU_AcsmSeq1x15 @0 {
       bits 16;
       access rw;
       reset 16'h0;
    }
  }
  register AcsmSeq1x16 @'h30 {
    field RFU_AcsmSeq1x16 @0 {
       bits 16;
       access rw;
       reset 16'h0;
    }
  }
  register AcsmSeq1x17 @'h31 {
    field RFU_AcsmSeq1x17 @0 {
       bits 16;
       access rw;
       reset 16'h0;
    }
  }
  register AcsmSeq1x18 @'h32 {
    field RFU_AcsmSeq1x18 @0 {
       bits 16;
       access rw;
       reset 16'h0;
    }
  }
  register AcsmSeq1x19 @'h33 {
    field RFU_AcsmSeq1x19 @0 {
       bits 16;
       access rw;
       reset 16'h0;
    }
  }
  register AcsmSeq1x20 @'h34 {
    field RFU_AcsmSeq1x20 @0 {
       bits 16;
       access rw;
       reset 16'h0;
    }
  }
  register AcsmSeq1x21 @'h35 {
    field RFU_AcsmSeq1x21 @0 {
       bits 16;
       access rw;
       reset 16'h0;
    }
  }
  register AcsmSeq1x22 @'h36 {
    field RFU_AcsmSeq1x22 @0 {
       bits 16;
       access rw;
       reset 16'h0;
    }
  }
  register AcsmSeq1x23 @'h37 {
    field RFU_AcsmSeq1x23 @0 {
       bits 16;
       access rw;
       reset 16'h0;
    }
  }
  register AcsmSeq1x24 @'h38 {
    field RFU_AcsmSeq1x24 @0 {
       bits 16;
       access rw;
       reset 16'h0;
    }
  }
  register AcsmSeq1x25 @'h39 {
    field RFU_AcsmSeq1x25 @0 {
       bits 16;
       access rw;
       reset 16'h0;
    }
  }
  register AcsmSeq1x26 @'h3a {
    field RFU_AcsmSeq1x26 @0 {
       bits 16;
       access rw;
       reset 16'h0;
    }
  }
  register AcsmSeq1x27 @'h3b {
    field RFU_AcsmSeq1x27 @0 {
       bits 16;
       access rw;
       reset 16'h0;
    }
  }
  register AcsmSeq1x28 @'h3c {
    field RFU_AcsmSeq1x28 @0 {
       bits 16;
       access rw;
       reset 16'h0;
    }
  }
  register AcsmSeq1x29 @'h3d {
    field RFU_AcsmSeq1x29 @0 {
       bits 16;
       access rw;
       reset 16'h0;
    }
  }
  register AcsmSeq1x30 @'h3e {
    field RFU_AcsmSeq1x30 @0 {
       bits 16;
       access rw;
       reset 16'h0;
    }
  }
  register AcsmSeq1x31 @'h3f {
    field RFU_AcsmSeq1x31 @0 {
       bits 16;
       access rw;
       reset 16'h0;
    }
  }
  register AcsmSeq2x0 @'h40 {
    field RFU_AcsmSeq2x0 @0 {
       bits 16;
       access rw;
       reset 16'h0;
    }
  }
  register AcsmSeq2x1 @'h41 {
    field RFU_AcsmSeq2x1 @0 {
       bits 16;
       access rw;
       reset 16'h0;
    }
  }
  register AcsmSeq2x2 @'h42 {
    field RFU_AcsmSeq2x2 @0 {
       bits 16;
       access rw;
       reset 16'h0;
    }
  }
  register AcsmSeq2x3 @'h43 {
    field RFU_AcsmSeq2x3 @0 {
       bits 16;
       access rw;
       reset 16'h0;
    }
  }
  register AcsmSeq2x4 @'h44 {
    field RFU_AcsmSeq2x4 @0 {
       bits 16;
       access rw;
       reset 16'h0;
    }
  }
  register AcsmSeq2x5 @'h45 {
    field RFU_AcsmSeq2x5 @0 {
       bits 16;
       access rw;
       reset 16'h0;
    }
  }
  register AcsmSeq2x6 @'h46 {
    field RFU_AcsmSeq2x6 @0 {
       bits 16;
       access rw;
       reset 16'h0;
    }
  }
  register AcsmSeq2x7 @'h47 {
    field RFU_AcsmSeq2x7 @0 {
       bits 16;
       access rw;
       reset 16'h0;
    }
  }
  register AcsmSeq2x8 @'h48 {
    field RFU_AcsmSeq2x8 @0 {
       bits 16;
       access rw;
       reset 16'h0;
    }
  }
  register AcsmSeq2x9 @'h49 {
    field RFU_AcsmSeq2x9 @0 {
       bits 16;
       access rw;
       reset 16'h0;
    }
  }
  register AcsmSeq2x10 @'h4a {
    field RFU_AcsmSeq2x10 @0 {
       bits 16;
       access rw;
       reset 16'h0;
    }
  }
  register AcsmSeq2x11 @'h4b {
    field RFU_AcsmSeq2x11 @0 {
       bits 16;
       access rw;
       reset 16'h0;
    }
  }
  register AcsmSeq2x12 @'h4c {
    field RFU_AcsmSeq2x12 @0 {
       bits 16;
       access rw;
       reset 16'h0;
    }
  }
  register AcsmSeq2x13 @'h4d {
    field RFU_AcsmSeq2x13 @0 {
       bits 16;
       access rw;
       reset 16'h0;
    }
  }
  register AcsmSeq2x14 @'h4e {
    field RFU_AcsmSeq2x14 @0 {
       bits 16;
       access rw;
       reset 16'h0;
    }
  }
  register AcsmSeq2x15 @'h4f {
    field RFU_AcsmSeq2x15 @0 {
       bits 16;
       access rw;
       reset 16'h0;
    }
  }
  register AcsmSeq2x16 @'h50 {
    field RFU_AcsmSeq2x16 @0 {
       bits 16;
       access rw;
       reset 16'h0;
    }
  }
  register AcsmSeq2x17 @'h51 {
    field RFU_AcsmSeq2x17 @0 {
       bits 16;
       access rw;
       reset 16'h0;
    }
  }
  register AcsmSeq2x18 @'h52 {
    field RFU_AcsmSeq2x18 @0 {
       bits 16;
       access rw;
       reset 16'h0;
    }
  }
  register AcsmSeq2x19 @'h53 {
    field RFU_AcsmSeq2x19 @0 {
       bits 16;
       access rw;
       reset 16'h0;
    }
  }
  register AcsmSeq2x20 @'h54 {
    field RFU_AcsmSeq2x20 @0 {
       bits 16;
       access rw;
       reset 16'h0;
    }
  }
  register AcsmSeq2x21 @'h55 {
    field RFU_AcsmSeq2x21 @0 {
       bits 16;
       access rw;
       reset 16'h0;
    }
  }
  register AcsmSeq2x22 @'h56 {
    field RFU_AcsmSeq2x22 @0 {
       bits 16;
       access rw;
       reset 16'h0;
    }
  }
  register AcsmSeq2x23 @'h57 {
    field RFU_AcsmSeq2x23 @0 {
       bits 16;
       access rw;
       reset 16'h0;
    }
  }
  register AcsmSeq2x24 @'h58 {
    field RFU_AcsmSeq2x24 @0 {
       bits 16;
       access rw;
       reset 16'h0;
    }
  }
  register AcsmSeq2x25 @'h59 {
    field RFU_AcsmSeq2x25 @0 {
       bits 16;
       access rw;
       reset 16'h0;
    }
  }
  register AcsmSeq2x26 @'h5a {
    field RFU_AcsmSeq2x26 @0 {
       bits 16;
       access rw;
       reset 16'h0;
    }
  }
  register AcsmSeq2x27 @'h5b {
    field RFU_AcsmSeq2x27 @0 {
       bits 16;
       access rw;
       reset 16'h0;
    }
  }
  register AcsmSeq2x28 @'h5c {
    field RFU_AcsmSeq2x28 @0 {
       bits 16;
       access rw;
       reset 16'h0;
    }
  }
  register AcsmSeq2x29 @'h5d {
    field RFU_AcsmSeq2x29 @0 {
       bits 16;
       access rw;
       reset 16'h0;
    }
  }
  register AcsmSeq2x30 @'h5e {
    field RFU_AcsmSeq2x30 @0 {
       bits 16;
       access rw;
       reset 16'h0;
    }
  }
  register AcsmSeq2x31 @'h5f {
    field RFU_AcsmSeq2x31 @0 {
       bits 16;
       access rw;
       reset 16'h0;
    }
  }
  register AcsmSeq3x0 @'h60 {
    field RFU_AcsmSeq3x0 @0 {
       bits 16;
       access rw;
       reset 16'h0;
    }
  }
  register AcsmSeq3x1 @'h61 {
    field RFU_AcsmSeq3x1 @0 {
       bits 16;
       access rw;
       reset 16'h0;
    }
  }
  register AcsmSeq3x2 @'h62 {
    field RFU_AcsmSeq3x2 @0 {
       bits 16;
       access rw;
       reset 16'h0;
    }
  }
  register AcsmSeq3x3 @'h63 {
    field RFU_AcsmSeq3x3 @0 {
       bits 16;
       access rw;
       reset 16'h0;
    }
  }
  register AcsmSeq3x4 @'h64 {
    field RFU_AcsmSeq3x4 @0 {
       bits 16;
       access rw;
       reset 16'h0;
    }
  }
  register AcsmSeq3x5 @'h65 {
    field RFU_AcsmSeq3x5 @0 {
       bits 16;
       access rw;
       reset 16'h0;
    }
  }
  register AcsmSeq3x6 @'h66 {
    field RFU_AcsmSeq3x6 @0 {
       bits 16;
       access rw;
       reset 16'h0;
    }
  }
  register AcsmSeq3x7 @'h67 {
    field RFU_AcsmSeq3x7 @0 {
       bits 16;
       access rw;
       reset 16'h0;
    }
  }
  register AcsmSeq3x8 @'h68 {
    field RFU_AcsmSeq3x8 @0 {
       bits 16;
       access rw;
       reset 16'h0;
    }
  }
  register AcsmSeq3x9 @'h69 {
    field RFU_AcsmSeq3x9 @0 {
       bits 16;
       access rw;
       reset 16'h0;
    }
  }
  register AcsmSeq3x10 @'h6a {
    field RFU_AcsmSeq3x10 @0 {
       bits 16;
       access rw;
       reset 16'h0;
    }
  }
  register AcsmSeq3x11 @'h6b {
    field RFU_AcsmSeq3x11 @0 {
       bits 16;
       access rw;
       reset 16'h0;
    }
  }
  register AcsmSeq3x12 @'h6c {
    field RFU_AcsmSeq3x12 @0 {
       bits 16;
       access rw;
       reset 16'h0;
    }
  }
  register AcsmSeq3x13 @'h6d {
    field RFU_AcsmSeq3x13 @0 {
       bits 16;
       access rw;
       reset 16'h0;
    }
  }
  register AcsmSeq3x14 @'h6e {
    field RFU_AcsmSeq3x14 @0 {
       bits 16;
       access rw;
       reset 16'h0;
    }
  }
  register AcsmSeq3x15 @'h6f {
    field RFU_AcsmSeq3x15 @0 {
       bits 16;
       access rw;
       reset 16'h0;
    }
  }
  register AcsmSeq3x16 @'h70 {
    field RFU_AcsmSeq3x16 @0 {
       bits 16;
       access rw;
       reset 16'h0;
    }
  }
  register AcsmSeq3x17 @'h71 {
    field RFU_AcsmSeq3x17 @0 {
       bits 16;
       access rw;
       reset 16'h0;
    }
  }
  register AcsmSeq3x18 @'h72 {
    field RFU_AcsmSeq3x18 @0 {
       bits 16;
       access rw;
       reset 16'h0;
    }
  }
  register AcsmSeq3x19 @'h73 {
    field RFU_AcsmSeq3x19 @0 {
       bits 16;
       access rw;
       reset 16'h0;
    }
  }
  register AcsmSeq3x20 @'h74 {
    field RFU_AcsmSeq3x20 @0 {
       bits 16;
       access rw;
       reset 16'h0;
    }
  }
  register AcsmSeq3x21 @'h75 {
    field RFU_AcsmSeq3x21 @0 {
       bits 16;
       access rw;
       reset 16'h0;
    }
  }
  register AcsmSeq3x22 @'h76 {
    field RFU_AcsmSeq3x22 @0 {
       bits 16;
       access rw;
       reset 16'h0;
    }
  }
  register AcsmSeq3x23 @'h77 {
    field RFU_AcsmSeq3x23 @0 {
       bits 16;
       access rw;
       reset 16'h0;
    }
  }
  register AcsmSeq3x24 @'h78 {
    field RFU_AcsmSeq3x24 @0 {
       bits 16;
       access rw;
       reset 16'h0;
    }
  }
  register AcsmSeq3x25 @'h79 {
    field RFU_AcsmSeq3x25 @0 {
       bits 16;
       access rw;
       reset 16'h0;
    }
  }
  register AcsmSeq3x26 @'h7a {
    field RFU_AcsmSeq3x26 @0 {
       bits 16;
       access rw;
       reset 16'h0;
    }
  }
  register AcsmSeq3x27 @'h7b {
    field RFU_AcsmSeq3x27 @0 {
       bits 16;
       access rw;
       reset 16'h0;
    }
  }
  register AcsmSeq3x28 @'h7c {
    field RFU_AcsmSeq3x28 @0 {
       bits 16;
       access rw;
       reset 16'h0;
    }
  }
  register AcsmSeq3x29 @'h7d {
    field RFU_AcsmSeq3x29 @0 {
       bits 16;
       access rw;
       reset 16'h0;
    }
  }
  register AcsmSeq3x30 @'h7e {
    field RFU_AcsmSeq3x30 @0 {
       bits 16;
       access rw;
       reset 16'h0;
    }
  }
  register AcsmSeq3x31 @'h7f {
    field RFU_AcsmSeq3x31 @0 {
       bits 16;
       access rw;
       reset 16'h0;
    }
  }
  register AcsmPlayback0x0_p0 @'h80 {
    field AcsmPlayback0x0_p0 @0 {
       bits 12;
       access rw;
       reset 12'h0;
    }
  }
  register AcsmPlayback1x0_p0 @'h81 {
    field AcsmPlayback1x0_p0 @0 {
       bits 12;
       access rw;
       reset 12'h0;
    }
  }
  register AcsmPlayback0x1_p0 @'h82 {
    field AcsmPlayback0x1_p0 @0 {
       bits 12;
       access rw;
       reset 12'h0;
    }
  }
  register AcsmPlayback1x1_p0 @'h83 {
    field AcsmPlayback1x1_p0 @0 {
       bits 12;
       access rw;
       reset 12'h0;
    }
  }
  register AcsmPlayback0x2_p0 @'h84 {
    field AcsmPlayback0x2_p0 @0 {
       bits 12;
       access rw;
       reset 12'h0;
    }
  }
  register AcsmPlayback1x2_p0 @'h85 {
    field AcsmPlayback1x2_p0 @0 {
       bits 12;
       access rw;
       reset 12'h0;
    }
  }
  register AcsmPlayback0x3_p0 @'h86 {
    field AcsmPlayback0x3_p0 @0 {
       bits 12;
       access rw;
       reset 12'h0;
    }
  }
  register AcsmPlayback1x3_p0 @'h87 {
    field AcsmPlayback1x3_p0 @0 {
       bits 12;
       access rw;
       reset 12'h0;
    }
  }
  register AcsmPlayback0x4_p0 @'h88 {
    field AcsmPlayback0x4_p0 @0 {
       bits 12;
       access rw;
       reset 12'h0;
    }
  }
  register AcsmPlayback1x4_p0 @'h89 {
    field AcsmPlayback1x4_p0 @0 {
       bits 12;
       access rw;
       reset 12'h0;
    }
  }
  register AcsmPlayback0x5_p0 @'h8a {
    field AcsmPlayback0x5_p0 @0 {
       bits 12;
       access rw;
       reset 12'h0;
    }
  }
  register AcsmPlayback1x5_p0 @'h8b {
    field AcsmPlayback1x5_p0 @0 {
       bits 12;
       access rw;
       reset 12'h0;
    }
  }
  register AcsmPlayback0x6_p0 @'h8c {
    field AcsmPlayback0x6_p0 @0 {
       bits 12;
       access rw;
       reset 12'h0;
    }
  }
  register AcsmPlayback1x6_p0 @'h8d {
    field AcsmPlayback1x6_p0 @0 {
       bits 12;
       access rw;
       reset 12'h0;
    }
  }
  register AcsmPlayback0x7_p0 @'h8e {
    field AcsmPlayback0x7_p0 @0 {
       bits 12;
       access rw;
       reset 12'h0;
    }
  }
  register AcsmPlayback1x7_p0 @'h8f {
    field AcsmPlayback1x7_p0 @0 {
       bits 12;
       access rw;
       reset 12'h0;
    }
  }
  register AcsmPStateOvrEn @'h90 {
    field AcsmPStateOvrEn @0 {
       bits 1;
       access rw;
       reset 1'h0;
    }
  }
  register AcsmPStateOvrVal @'h91 {
    field AcsmPStateOvrVal @0 {
       bits 4;
       access rw;
       reset 4'h0;
    }
  }
  register AcsmCtrl23 @'hc0 {
    field RFU_AcsmCtrl23 @0 {
       bits 13;
       access rw;
       reset 13'h0;
    }
  }
  register AcsmCkeVal @'hc2 {
    field AcsmCkeVal @0 {
       bits 4;
       access rw;
       reset 4'h0;
    }
  }
  register LowSpeedClockDivider @'hc8 {
    field LowSpeedClockDivider @0 {
       bits 6;
       access rw;
       reset 6'h0;
    }
  }
  register AcsmCsMapCtrl0 @'hd0 {
    field RFU_AcsmCsMapCtrl0 @0 {
       bits 15;
       access rw;
       reset 15'h0;
    }
  }
  register AcsmCsMapCtrl1 @'hd1 {
    field RFU_AcsmCsMapCtrl1 @0 {
       bits 15;
       access rw;
       reset 15'h0;
    }
  }
  register AcsmCsMapCtrl2 @'hd2 {
    field RFU_AcsmCsMapCtrl2 @0 {
       bits 15;
       access rw;
       reset 15'h0;
    }
  }
  register AcsmCsMapCtrl3 @'hd3 {
    field RFU_AcsmCsMapCtrl3 @0 {
       bits 15;
       access rw;
       reset 15'h0;
    }
  }
  register AcsmCsMapCtrl4 @'hd4 {
    field RFU_AcsmCsMapCtrl4 @0 {
       bits 15;
       access rw;
       reset 15'h0;
    }
  }
  register AcsmCsMapCtrl5 @'hd5 {
    field RFU_AcsmCsMapCtrl5 @0 {
       bits 15;
       access rw;
       reset 15'h0;
    }
  }
  register AcsmCsMapCtrl6 @'hd6 {
    field RFU_AcsmCsMapCtrl6 @0 {
       bits 15;
       access rw;
       reset 15'h0;
    }
  }
  register AcsmCsMapCtrl7 @'hd7 {
    field RFU_AcsmCsMapCtrl7 @0 {
       bits 15;
       access rw;
       reset 15'h0;
    }
  }
  register AcsmCsMapCtrl8 @'hd8 {
    field RFU_AcsmCsMapCtrl8 @0 {
       bits 15;
       access rw;
       reset 15'h0;
    }
  }
  register AcsmCsMapCtrl9 @'hd9 {
    field RFU_AcsmCsMapCtrl9 @0 {
       bits 15;
       access rw;
       reset 15'h0;
    }
  }
  register AcsmCsMapCtrl10 @'hda {
    field RFU_AcsmCsMapCtrl10 @0 {
       bits 15;
       access rw;
       reset 15'h0;
    }
  }
  register AcsmCsMapCtrl11 @'hdb {
    field RFU_AcsmCsMapCtrl11 @0 {
       bits 15;
       access rw;
       reset 15'h0;
    }
  }
  register AcsmCsMapCtrl12 @'hdc {
    field RFU_AcsmCsMapCtrl12 @0 {
       bits 15;
       access rw;
       reset 15'h0;
    }
  }
  register AcsmCsMapCtrl13 @'hdd {
    field RFU_AcsmCsMapCtrl13 @0 {
       bits 15;
       access rw;
       reset 15'h0;
    }
  }
  register AcsmCsMapCtrl14 @'hde {
    field RFU_AcsmCsMapCtrl14 @0 {
       bits 15;
       access rw;
       reset 15'h0;
    }
  }
  register AcsmCsMapCtrl15 @'hdf {
    field RFU_AcsmCsMapCtrl15 @0 {
       bits 15;
       access rw;
       reset 15'h0;
    }
  }
  register AcsmOdtCtrl0 @'he0 {
    field RFU_AcsmOdtCtrl0 @0 {
       bits 8;
       access rw;
       reset 8'h0;
    }
  }
  register AcsmOdtCtrl1 @'he1 {
    field RFU_AcsmOdtCtrl1 @0 {
       bits 8;
       access rw;
       reset 8'h0;
    }
  }
  register AcsmOdtCtrl2 @'he2 {
    field RFU_AcsmOdtCtrl2 @0 {
       bits 8;
       access rw;
       reset 8'h0;
    }
  }
  register AcsmOdtCtrl3 @'he3 {
    field RFU_AcsmOdtCtrl3 @0 {
       bits 8;
       access rw;
       reset 8'h0;
    }
  }
  register AcsmOdtCtrl4 @'he4 {
    field RFU_AcsmOdtCtrl4 @0 {
       bits 8;
       access rw;
       reset 8'h0;
    }
  }
  register AcsmOdtCtrl5 @'he5 {
    field RFU_AcsmOdtCtrl5 @0 {
       bits 8;
       access rw;
       reset 8'h0;
    }
  }
  register AcsmOdtCtrl6 @'he6 {
    field RFU_AcsmOdtCtrl6 @0 {
       bits 8;
       access rw;
       reset 8'h0;
    }
  }
  register AcsmOdtCtrl7 @'he7 {
    field RFU_AcsmOdtCtrl7 @0 {
       bits 8;
       access rw;
       reset 8'h0;
    }
  }
  register AcsmOdtCtrl8 @'he8 {
    field RFU_AcsmOdtCtrl8 @0 {
       bits 16;
       access rw;
       reset 16'h0;
    }
  }
  register AcsmCtrl16 @'he9 {
    field RFU_AcsmCtrl16 @0 {
       bits 16;
       access rw;
       reset 16'h0;
    }
  }
  register LowSpeedClockStopVal @'hea {
    field LowSpeedClockStopVal @0 {
       bits 1;
       access rw;
       reset 1'h0;
    }
  }
  register AcsmCtrl18 @'heb {
    field RFU_AcsmCtrl18 @0 {
       bits 2;
       access ro;
       reset 2'h0;
    }
  }
  register AcsmCtrl19 @'hec {
    field RFU_AcsmCtrl19 @0 {
       bits 3;
       access rw;
       reset 3'h0;
    }
  }
  register AcsmCtrl20 @'hed {
    field RFU_AcsmCtrl20 @0 {
       bits 16;
       access ro;
       reset 16'h0;
    }
  }
  register AcsmCtrl21 @'hee {
    field RFU_AcsmCtrl21 @0 {
       bits 12;
       access rw;
       reset 12'h0;
    }
  }
  register AcsmCtrl22 @'hef {
    field RFU_AcsmCtrl22 @0 {
       bits 12;
       access rw;
       reset 12'h0;
    }
  }
  register AcsmCtrl0 @'hf0 {
    field RFU_AcsmCtrl0 @0 {
       bits 16;
       access rw;
       reset 16'h0;
    }
  }
  register AcsmCtrl1 @'hf1 {
    field RFU_AcsmCtrl1 @0 {
       bits 16;
       access rw;
       reset 16'h0;
    }
  }
  register AcsmCtrl2 @'hf2 {
    field RFU_AcsmCtrl2 @0 {
       bits 5;
       access rw;
       reset 5'h0;
    }
  }
  register AcsmCtrl3 @'hf3 {
    field RFU_AcsmCtrl3 @0 {
       bits 5;
       access rw;
       reset 5'h0;
    }
  }
  register AcsmCtrl4 @'hf4 {
    field RFU_AcsmCtrl4 @0 {
       bits 5;
       access rw;
       reset 5'h0;
    }
  }
  register AcsmCtrl5 @'hf5 {
    field RFU_AcsmCtrl5 @0 {
       bits 14;
       access rw;
       reset 14'h0;
    }
  }
  register AcsmCtrl6 @'hf6 {
    field RFU_AcsmCtrl6 @0 {
       bits 11;
       access rw;
       reset 11'h0;
    }
  }
  register AcsmCtrl7 @'hf7 {
    field RFU_AcsmCtrl7 @0 {
       bits 16;
       access rw;
       reset 16'h0;
    }
  }
  register AcsmCtrl8 @'hf8 {
    field RFU_AcsmCtrl8 @0 {
       bits 16;
       access rw;
       reset 16'h0;
    }
  }
  register AcsmCtrl9 @'hf9 {
    field RFU_AcsmCtrl9 @0 {
       bits 16;
       access rw;
       reset 16'h0;
    }
  }
  register AcsmCtrl10 @'hfa {
    field RFU_AcsmCtrl10 @0 {
       bits 16;
       access rw;
       reset 16'h0;
    }
  }
  register AcsmCtrl11 @'hfb {
    field RFU_AcsmCtrl11 @0 {
       bits 16;
       access rw;
       reset 16'h0;
    }
  }
  register AcsmCtrl12 @'hfc {
    field RFU_AcsmCtrl12 @0 {
       bits 12;
       access rw;
       reset 12'h0;
    }
  }
  register AcsmCtrl13 @'hfd {
    field RFU_AcsmCtrl13 @0 {
       bits 4;
       access rw;
       reset 4'h0;
    }
  }
  register AcsmCtrl14 @'hfe {
    field RFU_AcsmCtrl14 @0 {
       bits 4;
       access rw;
       reset 4'h0;
    }
  }
  register AcsmCtrl15 @'hff {
    field RFU_AcsmCtrl15 @0 {
       bits 4;
       access rw;
       reset 4'h0;
    }
  }
  register AcsmPlayback0x0_p1 @'h100080 {
    field AcsmPlayback0x0_p1 @0 {
       bits 12;
       access rw;
       reset 12'h0;
    }
  }
  register AcsmPlayback1x0_p1 @'h100081 {
    field AcsmPlayback1x0_p1 @0 {
       bits 12;
       access rw;
       reset 12'h0;
    }
  }
  register AcsmPlayback0x1_p1 @'h100082 {
    field AcsmPlayback0x1_p1 @0 {
       bits 12;
       access rw;
       reset 12'h0;
    }
  }
  register AcsmPlayback1x1_p1 @'h100083 {
    field AcsmPlayback1x1_p1 @0 {
       bits 12;
       access rw;
       reset 12'h0;
    }
  }
  register AcsmPlayback0x2_p1 @'h100084 {
    field AcsmPlayback0x2_p1 @0 {
       bits 12;
       access rw;
       reset 12'h0;
    }
  }
  register AcsmPlayback1x2_p1 @'h100085 {
    field AcsmPlayback1x2_p1 @0 {
       bits 12;
       access rw;
       reset 12'h0;
    }
  }
  register AcsmPlayback0x3_p1 @'h100086 {
    field AcsmPlayback0x3_p1 @0 {
       bits 12;
       access rw;
       reset 12'h0;
    }
  }
  register AcsmPlayback1x3_p1 @'h100087 {
    field AcsmPlayback1x3_p1 @0 {
       bits 12;
       access rw;
       reset 12'h0;
    }
  }
  register AcsmPlayback0x4_p1 @'h100088 {
    field AcsmPlayback0x4_p1 @0 {
       bits 12;
       access rw;
       reset 12'h0;
    }
  }
  register AcsmPlayback1x4_p1 @'h100089 {
    field AcsmPlayback1x4_p1 @0 {
       bits 12;
       access rw;
       reset 12'h0;
    }
  }
  register AcsmPlayback0x5_p1 @'h10008a {
    field AcsmPlayback0x5_p1 @0 {
       bits 12;
       access rw;
       reset 12'h0;
    }
  }
  register AcsmPlayback1x5_p1 @'h10008b {
    field AcsmPlayback1x5_p1 @0 {
       bits 12;
       access rw;
       reset 12'h0;
    }
  }
  register AcsmPlayback0x6_p1 @'h10008c {
    field AcsmPlayback0x6_p1 @0 {
       bits 12;
       access rw;
       reset 12'h0;
    }
  }
  register AcsmPlayback1x6_p1 @'h10008d {
    field AcsmPlayback1x6_p1 @0 {
       bits 12;
       access rw;
       reset 12'h0;
    }
  }
  register AcsmPlayback0x7_p1 @'h10008e {
    field AcsmPlayback0x7_p1 @0 {
       bits 12;
       access rw;
       reset 12'h0;
    }
  }
  register AcsmPlayback1x7_p1 @'h10008f {
    field AcsmPlayback1x7_p1 @0 {
       bits 12;
       access rw;
       reset 12'h0;
    }
  }
  register AcsmPlayback0x0_p2 @'h200080 {
    field AcsmPlayback0x0_p2 @0 {
       bits 12;
       access rw;
       reset 12'h0;
    }
  }
  register AcsmPlayback1x0_p2 @'h200081 {
    field AcsmPlayback1x0_p2 @0 {
       bits 12;
       access rw;
       reset 12'h0;
    }
  }
  register AcsmPlayback0x1_p2 @'h200082 {
    field AcsmPlayback0x1_p2 @0 {
       bits 12;
       access rw;
       reset 12'h0;
    }
  }
  register AcsmPlayback1x1_p2 @'h200083 {
    field AcsmPlayback1x1_p2 @0 {
       bits 12;
       access rw;
       reset 12'h0;
    }
  }
  register AcsmPlayback0x2_p2 @'h200084 {
    field AcsmPlayback0x2_p2 @0 {
       bits 12;
       access rw;
       reset 12'h0;
    }
  }
  register AcsmPlayback1x2_p2 @'h200085 {
    field AcsmPlayback1x2_p2 @0 {
       bits 12;
       access rw;
       reset 12'h0;
    }
  }
  register AcsmPlayback0x3_p2 @'h200086 {
    field AcsmPlayback0x3_p2 @0 {
       bits 12;
       access rw;
       reset 12'h0;
    }
  }
  register AcsmPlayback1x3_p2 @'h200087 {
    field AcsmPlayback1x3_p2 @0 {
       bits 12;
       access rw;
       reset 12'h0;
    }
  }
  register AcsmPlayback0x4_p2 @'h200088 {
    field AcsmPlayback0x4_p2 @0 {
       bits 12;
       access rw;
       reset 12'h0;
    }
  }
  register AcsmPlayback1x4_p2 @'h200089 {
    field AcsmPlayback1x4_p2 @0 {
       bits 12;
       access rw;
       reset 12'h0;
    }
  }
  register AcsmPlayback0x5_p2 @'h20008a {
    field AcsmPlayback0x5_p2 @0 {
       bits 12;
       access rw;
       reset 12'h0;
    }
  }
  register AcsmPlayback1x5_p2 @'h20008b {
    field AcsmPlayback1x5_p2 @0 {
       bits 12;
       access rw;
       reset 12'h0;
    }
  }
  register AcsmPlayback0x6_p2 @'h20008c {
    field AcsmPlayback0x6_p2 @0 {
       bits 12;
       access rw;
       reset 12'h0;
    }
  }
  register AcsmPlayback1x6_p2 @'h20008d {
    field AcsmPlayback1x6_p2 @0 {
       bits 12;
       access rw;
       reset 12'h0;
    }
  }
  register AcsmPlayback0x7_p2 @'h20008e {
    field AcsmPlayback0x7_p2 @0 {
       bits 12;
       access rw;
       reset 12'h0;
    }
  }
  register AcsmPlayback1x7_p2 @'h20008f {
    field AcsmPlayback1x7_p2 @0 {
       bits 12;
       access rw;
       reset 12'h0;
    }
  }
  register AcsmPlayback0x0_p3 @'h300080 {
    field AcsmPlayback0x0_p3 @0 {
       bits 12;
       access rw;
       reset 12'h0;
    }
  }
  register AcsmPlayback1x0_p3 @'h300081 {
    field AcsmPlayback1x0_p3 @0 {
       bits 12;
       access rw;
       reset 12'h0;
    }
  }
  register AcsmPlayback0x1_p3 @'h300082 {
    field AcsmPlayback0x1_p3 @0 {
       bits 12;
       access rw;
       reset 12'h0;
    }
  }
  register AcsmPlayback1x1_p3 @'h300083 {
    field AcsmPlayback1x1_p3 @0 {
       bits 12;
       access rw;
       reset 12'h0;
    }
  }
  register AcsmPlayback0x2_p3 @'h300084 {
    field AcsmPlayback0x2_p3 @0 {
       bits 12;
       access rw;
       reset 12'h0;
    }
  }
  register AcsmPlayback1x2_p3 @'h300085 {
    field AcsmPlayback1x2_p3 @0 {
       bits 12;
       access rw;
       reset 12'h0;
    }
  }
  register AcsmPlayback0x3_p3 @'h300086 {
    field AcsmPlayback0x3_p3 @0 {
       bits 12;
       access rw;
       reset 12'h0;
    }
  }
  register AcsmPlayback1x3_p3 @'h300087 {
    field AcsmPlayback1x3_p3 @0 {
       bits 12;
       access rw;
       reset 12'h0;
    }
  }
  register AcsmPlayback0x4_p3 @'h300088 {
    field AcsmPlayback0x4_p3 @0 {
       bits 12;
       access rw;
       reset 12'h0;
    }
  }
  register AcsmPlayback1x4_p3 @'h300089 {
    field AcsmPlayback1x4_p3 @0 {
       bits 12;
       access rw;
       reset 12'h0;
    }
  }
  register AcsmPlayback0x5_p3 @'h30008a {
    field AcsmPlayback0x5_p3 @0 {
       bits 12;
       access rw;
       reset 12'h0;
    }
  }
  register AcsmPlayback1x5_p3 @'h30008b {
    field AcsmPlayback1x5_p3 @0 {
       bits 12;
       access rw;
       reset 12'h0;
    }
  }
  register AcsmPlayback0x6_p3 @'h30008c {
    field AcsmPlayback0x6_p3 @0 {
       bits 12;
       access rw;
       reset 12'h0;
    }
  }
  register AcsmPlayback1x6_p3 @'h30008d {
    field AcsmPlayback1x6_p3 @0 {
       bits 12;
       access rw;
       reset 12'h0;
    }
  }
  register AcsmPlayback0x7_p3 @'h30008e {
    field AcsmPlayback0x7_p3 @0 {
       bits 12;
       access rw;
       reset 12'h0;
    }
  }
  register AcsmPlayback1x7_p3 @'h30008f {
    field AcsmPlayback1x7_p3 @0 {
       bits 12;
       access rw;
       reset 12'h0;
    }
  }
}
block dwc_ddrphy_top_DWC_DDRPHYA_ANIB0 {
  endian little;
  bytes 2;
  register MtestMuxSel @'h1a {
    field MtestMuxSel @0 {
       bits 6;
       access rw;
       reset 6'h0;
    }
  }
  register AForceDrvCont @'h27 {
    field AForceDrvCont @0 {
       bits 4;
       access rw;
       reset 4'h0;
    }
  }
  register AForceTriCont @'h28 {
    field AForceTriCont @0 {
       bits 4;
       access rw;
       reset 4'h0;
    }
  }
  register ATxImpedance @'h43 {
    field ADrvStrenP @0 {
       bits 5;
       access rw;
       reset 5'h1f;
    }
    field ADrvStrenN @5 {
       bits 5;
       access rw;
       reset 5'h1f;
    }
  }
  register ATestPrbsErr @'h53 {
    field ATestPrbsErr @0 {
       bits 4;
       access ro;
       reset 4'h0;
    }
  }
  register ATxSlewRate @'h55 {
    field ATxPreP @0 {
       bits 4;
       access rw;
       reset 4'hf;
    }
    field ATxPreN @4 {
       bits 4;
       access rw;
       reset 4'hf;
    }
    field ATxPreDrvMode @8 {
       bits 3;
       access rw;
       reset 3'h7;
    }
  }
  register ATestPrbsErrCnt @'h56 {
    field ATestPrbsErrCnt @0 {
       bits 16;
       access ro;
       reset 16'h0;
    }
  }
  register ATxDly_p0 @'h80 {
    field ATxDly_p0 @0 {
       bits 7;
       access rw;
       reset 7'h0;
    }
  }
  register ATxDly_p1 @'h100080 {
    field ATxDly_p1 @0 {
       bits 7;
       access rw;
       reset 7'h0;
    }
  }
  register ATxDly_p2 @'h200080 {
    field ATxDly_p2 @0 {
       bits 7;
       access rw;
       reset 7'h0;
    }
  }
  register ATxDly_p3 @'h300080 {
    field ATxDly_p3 @0 {
       bits 7;
       access rw;
       reset 7'h0;
    }
  }
}
block dwc_ddrphy_top_DWC_DDRPHYA_ANIB1 {
  endian little;
  bytes 2;
  register MtestMuxSel @'h1a {
    field MtestMuxSel @0 {
       bits 6;
       access rw;
       reset 6'h0;
    }
  }
  register AForceDrvCont @'h27 {
    field AForceDrvCont @0 {
       bits 4;
       access rw;
       reset 4'h0;
    }
  }
  register AForceTriCont @'h28 {
    field AForceTriCont @0 {
       bits 4;
       access rw;
       reset 4'h0;
    }
  }
  register ATxImpedance @'h43 {
    field ADrvStrenP @0 {
       bits 5;
       access rw;
       reset 5'h1f;
    }
    field ADrvStrenN @5 {
       bits 5;
       access rw;
       reset 5'h1f;
    }
  }
  register ATestPrbsErr @'h53 {
    field ATestPrbsErr @0 {
       bits 4;
       access ro;
       reset 4'h0;
    }
  }
  register ATxSlewRate @'h55 {
    field ATxPreP @0 {
       bits 4;
       access rw;
       reset 4'hf;
    }
    field ATxPreN @4 {
       bits 4;
       access rw;
       reset 4'hf;
    }
    field ATxPreDrvMode @8 {
       bits 3;
       access rw;
       reset 3'h7;
    }
  }
  register ATestPrbsErrCnt @'h56 {
    field ATestPrbsErrCnt @0 {
       bits 16;
       access ro;
       reset 16'h0;
    }
  }
  register ATxDly_p0 @'h80 {
    field ATxDly_p0 @0 {
       bits 7;
       access rw;
       reset 7'h0;
    }
  }
  register ATxDly_p1 @'h100080 {
    field ATxDly_p1 @0 {
       bits 7;
       access rw;
       reset 7'h0;
    }
  }
  register ATxDly_p2 @'h200080 {
    field ATxDly_p2 @0 {
       bits 7;
       access rw;
       reset 7'h0;
    }
  }
  register ATxDly_p3 @'h300080 {
    field ATxDly_p3 @0 {
       bits 7;
       access rw;
       reset 7'h0;
    }
  }
}
block dwc_ddrphy_top_DWC_DDRPHYA_ANIB2 {
  endian little;
  bytes 2;
  register MtestMuxSel @'h1a {
    field MtestMuxSel @0 {
       bits 6;
       access rw;
       reset 6'h0;
    }
  }
  register AForceDrvCont @'h27 {
    field AForceDrvCont @0 {
       bits 4;
       access rw;
       reset 4'h0;
    }
  }
  register AForceTriCont @'h28 {
    field AForceTriCont @0 {
       bits 4;
       access rw;
       reset 4'h0;
    }
  }
  register ATxImpedance @'h43 {
    field ADrvStrenP @0 {
       bits 5;
       access rw;
       reset 5'h1f;
    }
    field ADrvStrenN @5 {
       bits 5;
       access rw;
       reset 5'h1f;
    }
  }
  register ATestPrbsErr @'h53 {
    field ATestPrbsErr @0 {
       bits 4;
       access ro;
       reset 4'h0;
    }
  }
  register ATxSlewRate @'h55 {
    field ATxPreP @0 {
       bits 4;
       access rw;
       reset 4'hf;
    }
    field ATxPreN @4 {
       bits 4;
       access rw;
       reset 4'hf;
    }
    field ATxPreDrvMode @8 {
       bits 3;
       access rw;
       reset 3'h7;
    }
  }
  register ATestPrbsErrCnt @'h56 {
    field ATestPrbsErrCnt @0 {
       bits 16;
       access ro;
       reset 16'h0;
    }
  }
  register ATxDly_p0 @'h80 {
    field ATxDly_p0 @0 {
       bits 7;
       access rw;
       reset 7'h0;
    }
  }
  register ATxDly_p1 @'h100080 {
    field ATxDly_p1 @0 {
       bits 7;
       access rw;
       reset 7'h0;
    }
  }
  register ATxDly_p2 @'h200080 {
    field ATxDly_p2 @0 {
       bits 7;
       access rw;
       reset 7'h0;
    }
  }
  register ATxDly_p3 @'h300080 {
    field ATxDly_p3 @0 {
       bits 7;
       access rw;
       reset 7'h0;
    }
  }
}
block dwc_ddrphy_top_DWC_DDRPHYA_ANIB3 {
  endian little;
  bytes 2;
  register MtestMuxSel @'h1a {
    field MtestMuxSel @0 {
       bits 6;
       access rw;
       reset 6'h0;
    }
  }
  register AForceDrvCont @'h27 {
    field AForceDrvCont @0 {
       bits 4;
       access rw;
       reset 4'h0;
    }
  }
  register AForceTriCont @'h28 {
    field AForceTriCont @0 {
       bits 4;
       access rw;
       reset 4'h0;
    }
  }
  register ATxImpedance @'h43 {
    field ADrvStrenP @0 {
       bits 5;
       access rw;
       reset 5'h1f;
    }
    field ADrvStrenN @5 {
       bits 5;
       access rw;
       reset 5'h1f;
    }
  }
  register ATestPrbsErr @'h53 {
    field ATestPrbsErr @0 {
       bits 4;
       access ro;
       reset 4'h0;
    }
  }
  register ATxSlewRate @'h55 {
    field ATxPreP @0 {
       bits 4;
       access rw;
       reset 4'hf;
    }
    field ATxPreN @4 {
       bits 4;
       access rw;
       reset 4'hf;
    }
    field ATxPreDrvMode @8 {
       bits 3;
       access rw;
       reset 3'h7;
    }
  }
  register ATestPrbsErrCnt @'h56 {
    field ATestPrbsErrCnt @0 {
       bits 16;
       access ro;
       reset 16'h0;
    }
  }
  register ATxDly_p0 @'h80 {
    field ATxDly_p0 @0 {
       bits 7;
       access rw;
       reset 7'h0;
    }
  }
  register ATxDly_p1 @'h100080 {
    field ATxDly_p1 @0 {
       bits 7;
       access rw;
       reset 7'h0;
    }
  }
  register ATxDly_p2 @'h200080 {
    field ATxDly_p2 @0 {
       bits 7;
       access rw;
       reset 7'h0;
    }
  }
  register ATxDly_p3 @'h300080 {
    field ATxDly_p3 @0 {
       bits 7;
       access rw;
       reset 7'h0;
    }
  }
}
block dwc_ddrphy_top_DWC_DDRPHYA_ANIB4 {
  endian little;
  bytes 2;
  register MtestMuxSel @'h1a {
    field MtestMuxSel @0 {
       bits 6;
       access rw;
       reset 6'h0;
    }
  }
  register AForceDrvCont @'h27 {
    field AForceDrvCont @0 {
       bits 4;
       access rw;
       reset 4'h0;
    }
  }
  register AForceTriCont @'h28 {
    field AForceTriCont @0 {
       bits 4;
       access rw;
       reset 4'h0;
    }
  }
  register ATxImpedance @'h43 {
    field ADrvStrenP @0 {
       bits 5;
       access rw;
       reset 5'h1f;
    }
    field ADrvStrenN @5 {
       bits 5;
       access rw;
       reset 5'h1f;
    }
  }
  register ATestPrbsErr @'h53 {
    field ATestPrbsErr @0 {
       bits 4;
       access ro;
       reset 4'h0;
    }
  }
  register ATxSlewRate @'h55 {
    field ATxPreP @0 {
       bits 4;
       access rw;
       reset 4'hf;
    }
    field ATxPreN @4 {
       bits 4;
       access rw;
       reset 4'hf;
    }
    field ATxPreDrvMode @8 {
       bits 3;
       access rw;
       reset 3'h7;
    }
  }
  register ATestPrbsErrCnt @'h56 {
    field ATestPrbsErrCnt @0 {
       bits 16;
       access ro;
       reset 16'h0;
    }
  }
  register ATxDly_p0 @'h80 {
    field ATxDly_p0 @0 {
       bits 7;
       access rw;
       reset 7'h0;
    }
  }
  register ATxDly_p1 @'h100080 {
    field ATxDly_p1 @0 {
       bits 7;
       access rw;
       reset 7'h0;
    }
  }
  register ATxDly_p2 @'h200080 {
    field ATxDly_p2 @0 {
       bits 7;
       access rw;
       reset 7'h0;
    }
  }
  register ATxDly_p3 @'h300080 {
    field ATxDly_p3 @0 {
       bits 7;
       access rw;
       reset 7'h0;
    }
  }
}
block dwc_ddrphy_top_DWC_DDRPHYA_ANIB5 {
  endian little;
  bytes 2;
  register MtestMuxSel @'h1a {
    field MtestMuxSel @0 {
       bits 6;
       access rw;
       reset 6'h0;
    }
  }
  register AForceDrvCont @'h27 {
    field AForceDrvCont @0 {
       bits 4;
       access rw;
       reset 4'h0;
    }
  }
  register AForceTriCont @'h28 {
    field AForceTriCont @0 {
       bits 4;
       access rw;
       reset 4'h0;
    }
  }
  register ATxImpedance @'h43 {
    field ADrvStrenP @0 {
       bits 5;
       access rw;
       reset 5'h1f;
    }
    field ADrvStrenN @5 {
       bits 5;
       access rw;
       reset 5'h1f;
    }
  }
  register ATestPrbsErr @'h53 {
    field ATestPrbsErr @0 {
       bits 4;
       access ro;
       reset 4'h0;
    }
  }
  register ATxSlewRate @'h55 {
    field ATxPreP @0 {
       bits 4;
       access rw;
       reset 4'hf;
    }
    field ATxPreN @4 {
       bits 4;
       access rw;
       reset 4'hf;
    }
    field ATxPreDrvMode @8 {
       bits 3;
       access rw;
       reset 3'h7;
    }
  }
  register ATestPrbsErrCnt @'h56 {
    field ATestPrbsErrCnt @0 {
       bits 16;
       access ro;
       reset 16'h0;
    }
  }
  register ATxDly_p0 @'h80 {
    field ATxDly_p0 @0 {
       bits 7;
       access rw;
       reset 7'h0;
    }
  }
  register ATxDly_p1 @'h100080 {
    field ATxDly_p1 @0 {
       bits 7;
       access rw;
       reset 7'h0;
    }
  }
  register ATxDly_p2 @'h200080 {
    field ATxDly_p2 @0 {
       bits 7;
       access rw;
       reset 7'h0;
    }
  }
  register ATxDly_p3 @'h300080 {
    field ATxDly_p3 @0 {
       bits 7;
       access rw;
       reset 7'h0;
    }
  }
}
block dwc_ddrphy_top_DWC_DDRPHYA_ANIB6 {
  endian little;
  bytes 2;
  register MtestMuxSel @'h1a {
    field MtestMuxSel @0 {
       bits 6;
       access rw;
       reset 6'h0;
    }
  }
  register AForceDrvCont @'h27 {
    field AForceDrvCont @0 {
       bits 4;
       access rw;
       reset 4'h0;
    }
  }
  register AForceTriCont @'h28 {
    field AForceTriCont @0 {
       bits 4;
       access rw;
       reset 4'h0;
    }
  }
  register ATxImpedance @'h43 {
    field ADrvStrenP @0 {
       bits 5;
       access rw;
       reset 5'h1f;
    }
    field ADrvStrenN @5 {
       bits 5;
       access rw;
       reset 5'h1f;
    }
  }
  register ATestPrbsErr @'h53 {
    field ATestPrbsErr @0 {
       bits 4;
       access ro;
       reset 4'h0;
    }
  }
  register ATxSlewRate @'h55 {
    field ATxPreP @0 {
       bits 4;
       access rw;
       reset 4'hf;
    }
    field ATxPreN @4 {
       bits 4;
       access rw;
       reset 4'hf;
    }
    field ATxPreDrvMode @8 {
       bits 3;
       access rw;
       reset 3'h7;
    }
  }
  register ATestPrbsErrCnt @'h56 {
    field ATestPrbsErrCnt @0 {
       bits 16;
       access ro;
       reset 16'h0;
    }
  }
  register ATxDly_p0 @'h80 {
    field ATxDly_p0 @0 {
       bits 7;
       access rw;
       reset 7'h0;
    }
  }
  register ATxDly_p1 @'h100080 {
    field ATxDly_p1 @0 {
       bits 7;
       access rw;
       reset 7'h0;
    }
  }
  register ATxDly_p2 @'h200080 {
    field ATxDly_p2 @0 {
       bits 7;
       access rw;
       reset 7'h0;
    }
  }
  register ATxDly_p3 @'h300080 {
    field ATxDly_p3 @0 {
       bits 7;
       access rw;
       reset 7'h0;
    }
  }
}
block dwc_ddrphy_top_DWC_DDRPHYA_ANIB7 {
  endian little;
  bytes 2;
  register MtestMuxSel @'h1a {
    field MtestMuxSel @0 {
       bits 6;
       access rw;
       reset 6'h0;
    }
  }
  register AForceDrvCont @'h27 {
    field AForceDrvCont @0 {
       bits 4;
       access rw;
       reset 4'h0;
    }
  }
  register AForceTriCont @'h28 {
    field AForceTriCont @0 {
       bits 4;
       access rw;
       reset 4'h0;
    }
  }
  register ATxImpedance @'h43 {
    field ADrvStrenP @0 {
       bits 5;
       access rw;
       reset 5'h1f;
    }
    field ADrvStrenN @5 {
       bits 5;
       access rw;
       reset 5'h1f;
    }
  }
  register ATestPrbsErr @'h53 {
    field ATestPrbsErr @0 {
       bits 4;
       access ro;
       reset 4'h0;
    }
  }
  register ATxSlewRate @'h55 {
    field ATxPreP @0 {
       bits 4;
       access rw;
       reset 4'hf;
    }
    field ATxPreN @4 {
       bits 4;
       access rw;
       reset 4'hf;
    }
    field ATxPreDrvMode @8 {
       bits 3;
       access rw;
       reset 3'h7;
    }
  }
  register ATestPrbsErrCnt @'h56 {
    field ATestPrbsErrCnt @0 {
       bits 16;
       access ro;
       reset 16'h0;
    }
  }
  register ATxDly_p0 @'h80 {
    field ATxDly_p0 @0 {
       bits 7;
       access rw;
       reset 7'h0;
    }
  }
  register ATxDly_p1 @'h100080 {
    field ATxDly_p1 @0 {
       bits 7;
       access rw;
       reset 7'h0;
    }
  }
  register ATxDly_p2 @'h200080 {
    field ATxDly_p2 @0 {
       bits 7;
       access rw;
       reset 7'h0;
    }
  }
  register ATxDly_p3 @'h300080 {
    field ATxDly_p3 @0 {
       bits 7;
       access rw;
       reset 7'h0;
    }
  }
}
block dwc_ddrphy_top_DWC_DDRPHYA_ANIB8 {
  endian little;
  bytes 2;
  register MtestMuxSel @'h1a {
    field MtestMuxSel @0 {
       bits 6;
       access rw;
       reset 6'h0;
    }
  }
  register AForceDrvCont @'h27 {
    field AForceDrvCont @0 {
       bits 4;
       access rw;
       reset 4'h0;
    }
  }
  register AForceTriCont @'h28 {
    field AForceTriCont @0 {
       bits 4;
       access rw;
       reset 4'h0;
    }
  }
  register ATxImpedance @'h43 {
    field ADrvStrenP @0 {
       bits 5;
       access rw;
       reset 5'h1f;
    }
    field ADrvStrenN @5 {
       bits 5;
       access rw;
       reset 5'h1f;
    }
  }
  register ATestPrbsErr @'h53 {
    field ATestPrbsErr @0 {
       bits 4;
       access ro;
       reset 4'h0;
    }
  }
  register ATxSlewRate @'h55 {
    field ATxPreP @0 {
       bits 4;
       access rw;
       reset 4'hf;
    }
    field ATxPreN @4 {
       bits 4;
       access rw;
       reset 4'hf;
    }
    field ATxPreDrvMode @8 {
       bits 3;
       access rw;
       reset 3'h7;
    }
  }
  register ATestPrbsErrCnt @'h56 {
    field ATestPrbsErrCnt @0 {
       bits 16;
       access ro;
       reset 16'h0;
    }
  }
  register ATxDly_p0 @'h80 {
    field ATxDly_p0 @0 {
       bits 7;
       access rw;
       reset 7'h0;
    }
  }
  register ATxDly_p1 @'h100080 {
    field ATxDly_p1 @0 {
       bits 7;
       access rw;
       reset 7'h0;
    }
  }
  register ATxDly_p2 @'h200080 {
    field ATxDly_p2 @0 {
       bits 7;
       access rw;
       reset 7'h0;
    }
  }
  register ATxDly_p3 @'h300080 {
    field ATxDly_p3 @0 {
       bits 7;
       access rw;
       reset 7'h0;
    }
  }
}
block dwc_ddrphy_top_DWC_DDRPHYA_ANIB9 {
  endian little;
  bytes 2;
  register MtestMuxSel @'h1a {
    field MtestMuxSel @0 {
       bits 6;
       access rw;
       reset 6'h0;
    }
  }
  register AForceDrvCont @'h27 {
    field AForceDrvCont @0 {
       bits 4;
       access rw;
       reset 4'h0;
    }
  }
  register AForceTriCont @'h28 {
    field AForceTriCont @0 {
       bits 4;
       access rw;
       reset 4'h0;
    }
  }
  register ATxImpedance @'h43 {
    field ADrvStrenP @0 {
       bits 5;
       access rw;
       reset 5'h1f;
    }
    field ADrvStrenN @5 {
       bits 5;
       access rw;
       reset 5'h1f;
    }
  }
  register ATestPrbsErr @'h53 {
    field ATestPrbsErr @0 {
       bits 4;
       access ro;
       reset 4'h0;
    }
  }
  register ATxSlewRate @'h55 {
    field ATxPreP @0 {
       bits 4;
       access rw;
       reset 4'hf;
    }
    field ATxPreN @4 {
       bits 4;
       access rw;
       reset 4'hf;
    }
    field ATxPreDrvMode @8 {
       bits 3;
       access rw;
       reset 3'h7;
    }
  }
  register ATestPrbsErrCnt @'h56 {
    field ATestPrbsErrCnt @0 {
       bits 16;
       access ro;
       reset 16'h0;
    }
  }
  register ATxDly_p0 @'h80 {
    field ATxDly_p0 @0 {
       bits 7;
       access rw;
       reset 7'h0;
    }
  }
  register ATxDly_p1 @'h100080 {
    field ATxDly_p1 @0 {
       bits 7;
       access rw;
       reset 7'h0;
    }
  }
  register ATxDly_p2 @'h200080 {
    field ATxDly_p2 @0 {
       bits 7;
       access rw;
       reset 7'h0;
    }
  }
  register ATxDly_p3 @'h300080 {
    field ATxDly_p3 @0 {
       bits 7;
       access rw;
       reset 7'h0;
    }
  }
}
block dwc_ddrphy_top_DWC_DDRPHYA_ANIB10 {
  endian little;
  bytes 2;
  register MtestMuxSel @'h1a {
    field MtestMuxSel @0 {
       bits 6;
       access rw;
       reset 6'h0;
    }
  }
  register AForceDrvCont @'h27 {
    field AForceDrvCont @0 {
       bits 4;
       access rw;
       reset 4'h0;
    }
  }
  register AForceTriCont @'h28 {
    field AForceTriCont @0 {
       bits 4;
       access rw;
       reset 4'h0;
    }
  }
  register ATxImpedance @'h43 {
    field ADrvStrenP @0 {
       bits 5;
       access rw;
       reset 5'h1f;
    }
    field ADrvStrenN @5 {
       bits 5;
       access rw;
       reset 5'h1f;
    }
  }
  register ATestPrbsErr @'h53 {
    field ATestPrbsErr @0 {
       bits 4;
       access ro;
       reset 4'h0;
    }
  }
  register ATxSlewRate @'h55 {
    field ATxPreP @0 {
       bits 4;
       access rw;
       reset 4'hf;
    }
    field ATxPreN @4 {
       bits 4;
       access rw;
       reset 4'hf;
    }
    field ATxPreDrvMode @8 {
       bits 3;
       access rw;
       reset 3'h7;
    }
  }
  register ATestPrbsErrCnt @'h56 {
    field ATestPrbsErrCnt @0 {
       bits 16;
       access ro;
       reset 16'h0;
    }
  }
  register ATxDly_p0 @'h80 {
    field ATxDly_p0 @0 {
       bits 7;
       access rw;
       reset 7'h0;
    }
  }
  register ATxDly_p1 @'h100080 {
    field ATxDly_p1 @0 {
       bits 7;
       access rw;
       reset 7'h0;
    }
  }
  register ATxDly_p2 @'h200080 {
    field ATxDly_p2 @0 {
       bits 7;
       access rw;
       reset 7'h0;
    }
  }
  register ATxDly_p3 @'h300080 {
    field ATxDly_p3 @0 {
       bits 7;
       access rw;
       reset 7'h0;
    }
  }
}
block dwc_ddrphy_top_DWC_DDRPHYA_ANIB11 {
  endian little;
  bytes 2;
  register MtestMuxSel @'h1a {
    field MtestMuxSel @0 {
       bits 6;
       access rw;
       reset 6'h0;
    }
  }
  register AForceDrvCont @'h27 {
    field AForceDrvCont @0 {
       bits 4;
       access rw;
       reset 4'h0;
    }
  }
  register AForceTriCont @'h28 {
    field AForceTriCont @0 {
       bits 4;
       access rw;
       reset 4'h0;
    }
  }
  register ATxImpedance @'h43 {
    field ADrvStrenP @0 {
       bits 5;
       access rw;
       reset 5'h1f;
    }
    field ADrvStrenN @5 {
       bits 5;
       access rw;
       reset 5'h1f;
    }
  }
  register ATestPrbsErr @'h53 {
    field ATestPrbsErr @0 {
       bits 4;
       access ro;
       reset 4'h0;
    }
  }
  register ATxSlewRate @'h55 {
    field ATxPreP @0 {
       bits 4;
       access rw;
       reset 4'hf;
    }
    field ATxPreN @4 {
       bits 4;
       access rw;
       reset 4'hf;
    }
    field ATxPreDrvMode @8 {
       bits 3;
       access rw;
       reset 3'h7;
    }
  }
  register ATestPrbsErrCnt @'h56 {
    field ATestPrbsErrCnt @0 {
       bits 16;
       access ro;
       reset 16'h0;
    }
  }
  register ATxDly_p0 @'h80 {
    field ATxDly_p0 @0 {
       bits 7;
       access rw;
       reset 7'h0;
    }
  }
  register ATxDly_p1 @'h100080 {
    field ATxDly_p1 @0 {
       bits 7;
       access rw;
       reset 7'h0;
    }
  }
  register ATxDly_p2 @'h200080 {
    field ATxDly_p2 @0 {
       bits 7;
       access rw;
       reset 7'h0;
    }
  }
  register ATxDly_p3 @'h300080 {
    field ATxDly_p3 @0 {
       bits 7;
       access rw;
       reset 7'h0;
    }
  }
}
block dwc_ddrphy_top_DWC_DDRPHYA_APBONLY0 {
  endian little;
  bytes 2;
  register MicroContMuxSel @'h0 {
    field MicroContMuxSel @0 {
       bits 1;
       access rw;
       reset 1'h0;
    }
  }
  register UctShadowRegs @'h4 {
    field UctWriteProtShadow @0 {
       bits 1;
       access ro;
       reset 1'h0;
    }
    field UctDatWriteProtShadow @1 {
       bits 1;
       access ro;
       reset 1'h0;
    }
  }
  register DctWriteOnly @'h30 {
    field DctWriteOnly @0 {
       bits 16;
       access rw;
       reset 16'h0;
    }
  }
  register DctWriteProt @'h31 {
    field DctWriteProt @0 {
       bits 1;
       access rw;
       reset 1'h1;
    }
  }
  register UctWriteOnlyShadow @'h32 {
    field UctWriteOnlyShadow @0 {
       bits 16;
       access ro;
       reset 16'h0;
    }
  }
  register UctDatWriteOnlyShadow @'h34 {
    field UctDatWriteOnlyShadow @0 {
       bits 16;
       access ro;
       reset 16'h0;
    }
  }
  register NeverGateCsrClock @'h35 {
    field NeverGateCsrClock @0 {
       bits 1;
       access rw;
       reset 1'h0;
    }
  }
  register DfiCfgRdDataValidTicks @'h37 {
    field DfiCfgRdDataValidTicks @0 {
       bits 6;
       access rw;
       reset 6'h6;
    }
  }
  register MicroReset @'h99 {
    field StallToMicro @0 {
       bits 1;
       access rw;
       reset 1'h1;
    }
    field TestWakeup @1 {
       bits 1;
       access rw;
       reset 1'h0;
    }
    field RSVDMicro @2 {
       bits 1;
       access rw;
       reset 1'h0;
    }
    field ResetToMicro @3 {
       bits 1;
       access rw;
       reset 1'h0;
    }
  }
  register SequencerOverride @'he7 {
    field RFU_SequencerOverride @0 {
       bits 11;
       access rw;
       reset 11'h80;
    }
  }
  register DfiInitCompleteShadow @'hfa {
    field DfiInitCompleteShadow @0 {
       bits 1;
       access ro;
       reset 1'h0;
    }
  }
}
block dwc_ddrphy_top_DWC_DDRPHYA_DBYTE0 {
  endian little;
  bytes 2;
  register DbyteMiscMode @'h0 {
    field Reserved @0 {
       bits 2;
    }
    field DByteDisable @2 {
       bits 1;
       access rw;
       reset 1'h0;
    }
  }
  register TsmByte0 @'h1 {
    field RFU_TsmByte0 @0 {
       bits 16;
       access rw;
       reset 16'h0;
    }
  }
  register TrainingParam @'h2 {
    field RFU_TrainingParam @0 {
       bits 16;
       access rw;
       reset 16'h0;
    }
  }
  register UseDqsEnReplica_p0 @'h3 {
    field UseDqsEnReplica_p0 @0 {
       bits 1;
       access rw;
       reset 1'h0;
    }
  }
  register RxTrainPatternEnable @'h10 {
    field RxTrainPatternEnable @0 {
       bits 1;
       access rw;
       reset 1'h0;
    }
  }
  register TsmByte1 @'h11 {
    field RFU_TsmByte1 @0 {
       bits 16;
       access rw;
       reset 16'h0;
    }
  }
  register TsmByte2 @'h12 {
    field RFU_TsmByte2 @0 {
       bits 16;
       access rw;
       reset 16'h0;
    }
  }
  register TsmByte3 @'h13 {
    field RFU_TsmByte3 @0 {
       bits 9;
       access rw;
       reset 9'h0;
    }
  }
  register TsmByte4 @'h14 {
    field RFU_TsmByte4 @0 {
       bits 4;
       access rw;
       reset 4'h0;
    }
  }
  register TestModeConfig @'h17 {
    field RFU_TestModeConfig @0 {
       bits 10;
       access rw;
       reset 10'h0;
    }
  }
  register TsmByte5 @'h18 {
    field RFU_TsmByte5 @0 {
       bits 16;
       access rw;
       reset 16'h0;
    }
  }
  register MtestMuxSel @'h1a {
    field MtestMuxSel @0 {
       bits 6;
       access rw;
       reset 6'h0;
    }
  }
  register DtsmTrainModeCtrl @'h1f {
    field RFU_DtsmTrainModeCtrl @0 {
       bits 4;
       access rw;
       reset 4'h0;
    }
  }
  register DFIMRL_p0 @'h20 {
    field DFIMRL_p0 @0 {
       bits 5;
       access rw;
       reset 5'h6;
    }
  }
  register AsyncDbyteMode @'h24 {
    field AsyncDbyteMode @0 {
       bits 9;
       access rw;
       reset 9'h0;
    }
  }
  register AsyncDbyteTxEn @'h26 {
    field AsyncDbyteTxEn @0 {
       bits 12;
       access rw;
       reset 12'h0;
    }
  }
  register AsyncDbyteTxData @'h28 {
    field AsyncDbyteTxData @0 {
       bits 12;
       access rw;
       reset 12'h0;
    }
  }
  register AsyncDbyteRxData @'h2a {
    field AsyncDbyteRxData @0 {
       bits 12;
       access ro;
       reset 12'h0;
    }
  }
  register VrefDAC1_r0 @'h30 {
    field VrefDAC1_r0 @0 {
       bits 7;
       access rw;
       reset 7'h0;
    }
  }
  register TrainingCntr_r0 @'h32 {
    field RFU_TrainingCntr_r0 @0 {
       bits 16;
       access rw;
       reset 16'h0;
    }
  }
  register VrefDAC0_r0 @'h40 {
    field VrefDAC0_r0 @0 {
       bits 7;
       access rw;
       reset 7'h0;
    }
  }
  register TxImpedanceCtrl0_b0_p0 @'h41 {
    field DrvStrenDqP @0 {
       bits 6;
       access rw;
       reset 6'h3f;
    }
    field DrvStrenDqN @6 {
       bits 6;
       access rw;
       reset 6'h3f;
    }
  }
  register DqDqsRcvCntrl_b0_p0 @'h43 {
    field SelAnalogVref @0 {
       bits 1;
       access rw;
       reset 1'h0;
    }
    field ExtVrefRange @1 {
       bits 1;
       access rw;
       reset 1'h0;
    }
    field DfeCtrl @2 {
       bits 2;
       access rw;
       reset 2'h0;
    }
    field MajorModeDbyte @4 {
       bits 3;
       access rw;
       reset 3'h3;
    }
    field GainCurrAdj @7 {
       bits 5;
       access rw;
       reset 5'hb;
    }
    field Reserved @12 {
       bits 4;
    }
  }
  register TxEqualizationMode_p0 @'h48 {
    field TxEqMode @0 {
       bits 2;
       access rw;
       reset 2'h0;
    }
  }
  register TxImpedanceCtrl1_b0_p0 @'h49 {
    field DrvStrenFSDqP @0 {
       bits 6;
       access rw;
       reset 6'h3f;
    }
    field DrvStrenFSDqN @6 {
       bits 6;
       access rw;
       reset 6'h3f;
    }
  }
  register DqDqsRcvCntrl1 @'h4a {
    field PowerDownRcvr @0 {
       bits 9;
       access rw;
       reset 9'h0;
    }
    field PowerDownRcvrDqs @9 {
       bits 1;
       access rw;
       reset 1'h0;
    }
    field RxPadStandbyEn @10 {
       bits 1;
       access rw;
       reset 1'h1;
    }
    field EnLPReqPDR @11 {
       bits 1;
       access rw;
       reset 1'h0;
    }
  }
  register TxImpedanceCtrl2_b0_p0 @'h4b {
    field DrvStrenEQHiDqP @0 {
       bits 6;
       access rw;
       reset 6'h0;
    }
    field DrvStrenEQLoDqN @6 {
       bits 6;
       access rw;
       reset 6'h0;
    }
  }
  register DqDqsRcvCntrl2_p0 @'h4c {
    field EnRxAgressivePDR @0 {
       bits 1;
       access rw;
       reset 1'h0;
    }
  }
  register TxOdtDrvStren_b0_p0 @'h4d {
    field ODTStrenP @0 {
       bits 6;
       access rw;
       reset 6'h0;
    }
    field ODTStrenN @6 {
       bits 6;
       access rw;
       reset 6'h0;
    }
  }
  register RxFifoCheckStatus @'h56 {
    field RxFifoLocErr @0 {
       bits 1;
       access ro;
       reset 1'h0;
    }
    field RxFifoLocUErr @1 {
       bits 1;
       access ro;
       reset 1'h0;
    }
  }
  register RxFifoCheckErrValues @'h57 {
    field RxFifoRdLocErrValue @0 {
       bits 4;
       access ro;
       reset 4'h0;
    }
    field RxFifoWrLocErrValue @4 {
       bits 4;
       access ro;
       reset 4'h0;
    }
    field RxFifoRdLocUErrValue @8 {
       bits 4;
       access ro;
       reset 4'h0;
    }
    field RxFifoWrLocUErrValue @12 {
       bits 4;
       access ro;
       reset 4'h0;
    }
  }
  register RxFifoInfo @'h58 {
    field RxFifoRdLoc @0 {
       bits 4;
       access ro;
       reset 4'h0;
    }
    field RxFifoWrLoc @4 {
       bits 4;
       access ro;
       reset 4'h0;
    }
    field RxFifoRdLocU @8 {
       bits 4;
       access ro;
       reset 4'h0;
    }
    field RxFifoWrLocU @12 {
       bits 4;
       access ro;
       reset 4'h0;
    }
  }
  register RxFifoVisibility @'h59 {
    field RxFifoRdPtr @0 {
       bits 3;
       access rw;
       reset 3'h0;
    }
    field RxFifoRdPtrOvr @3 {
       bits 1;
       access rw;
       reset 1'h0;
    }
    field RxFifoRdEn @4 {
       bits 1;
       access rw;
       reset 1'h0;
    }
  }
  register RxFifoContentsDQ3210 @'h5a {
    field RxFifoContentsDQ3210 @0 {
       bits 16;
       access ro;
       reset 16'h0;
    }
  }
  register RxFifoContentsDQ7654 @'h5b {
    field RxFifoContentsDQ7654 @0 {
       bits 16;
       access ro;
       reset 16'h0;
    }
  }
  register RxFifoContentsDBI @'h5c {
    field RxFifoContentsDBI @0 {
       bits 4;
       access ro;
       reset 4'h0;
    }
  }
  register TxSlewRate_b0_p0 @'h5f {
    field TxPreP @0 {
       bits 4;
       access rw;
       reset 4'hf;
    }
    field TxPreN @4 {
       bits 4;
       access rw;
       reset 4'hf;
    }
    field TxPreDrvMode @8 {
       bits 3;
       access rw;
       reset 3'h7;
    }
  }
  register TrainingIncDecDtsmEn_r0 @'h62 {
    field TrainingIncDecDtsmEn_r0 @0 {
       bits 9;
       access rw;
       reset 9'h0;
    }
  }
  register RxPBDlyTg0_r0 @'h68 {
    field RxPBDlyTg0_r0 @0 {
       bits 7;
       access rw;
       reset 7'h0;
    }
  }
  register RxPBDlyTg1_r0 @'h69 {
    field RxPBDlyTg1_r0 @0 {
       bits 7;
       access rw;
       reset 7'h0;
    }
  }
  register RxPBDlyTg2_r0 @'h6a {
    field RxPBDlyTg2_r0 @0 {
       bits 7;
       access rw;
       reset 7'h0;
    }
  }
  register RxPBDlyTg3_r0 @'h6b {
    field RxPBDlyTg3_r0 @0 {
       bits 7;
       access rw;
       reset 7'h0;
    }
  }
  register RxEnDlyTg0_u0_p0 @'h80 {
    field RxEnDlyTg0_u0_p0 @0 {
       bits 11;
       access rw;
       reset 11'h100;
    }
  }
  register RxEnDlyTg1_u0_p0 @'h81 {
    field RxEnDlyTg1_u0_p0 @0 {
       bits 11;
       access rw;
       reset 11'h100;
    }
  }
  register RxEnDlyTg2_u0_p0 @'h82 {
    field RxEnDlyTg2_u0_p0 @0 {
       bits 11;
       access rw;
       reset 11'h100;
    }
  }
  register RxEnDlyTg3_u0_p0 @'h83 {
    field RxEnDlyTg3_u0_p0 @0 {
       bits 11;
       access rw;
       reset 11'h100;
    }
  }
  register RxClkDlyTg0_u0_p0 @'h8c {
    field RxClkDlyTg0_u0_p0 @0 {
       bits 6;
       access rw;
       reset 6'h10;
    }
  }
  register RxClkDlyTg1_u0_p0 @'h8d {
    field RxClkDlyTg1_u0_p0 @0 {
       bits 6;
       access rw;
       reset 6'h10;
    }
  }
  register RxClkDlyTg2_u0_p0 @'h8e {
    field RxClkDlyTg2_u0_p0 @0 {
       bits 6;
       access rw;
       reset 6'h10;
    }
  }
  register RxClkDlyTg3_u0_p0 @'h8f {
    field RxClkDlyTg3_u0_p0 @0 {
       bits 6;
       access rw;
       reset 6'h10;
    }
  }
  register RxClkcDlyTg0_u0_p0 @'h90 {
    field RxClkcDlyTg0_u0_p0 @0 {
       bits 6;
       access rw;
       reset 6'h10;
    }
  }
  register RxClkcDlyTg1_u0_p0 @'h91 {
    field RxClkcDlyTg1_u0_p0 @0 {
       bits 6;
       access rw;
       reset 6'h10;
    }
  }
  register RxClkcDlyTg2_u0_p0 @'h92 {
    field RxClkcDlyTg2_u0_p0 @0 {
       bits 6;
       access rw;
       reset 6'h10;
    }
  }
  register RxClkcDlyTg3_u0_p0 @'h93 {
    field RxClkcDlyTg3_u0_p0 @0 {
       bits 6;
       access rw;
       reset 6'h10;
    }
  }
  register Dq0LnSel @'ha0 {
    field Dq0LnSel @0 {
       bits 3;
       access rw;
       reset 3'h0;
    }
  }
  register Dq1LnSel @'ha1 {
    field Dq1LnSel @0 {
       bits 3;
       access rw;
       reset 3'h1;
    }
  }
  register Dq2LnSel @'ha2 {
    field Dq2LnSel @0 {
       bits 3;
       access rw;
       reset 3'h2;
    }
  }
  register Dq3LnSel @'ha3 {
    field Dq3LnSel @0 {
       bits 3;
       access rw;
       reset 3'h3;
    }
  }
  register Dq4LnSel @'ha4 {
    field Dq4LnSel @0 {
       bits 3;
       access rw;
       reset 3'h4;
    }
  }
  register Dq5LnSel @'ha5 {
    field Dq5LnSel @0 {
       bits 3;
       access rw;
       reset 3'h5;
    }
  }
  register Dq6LnSel @'ha6 {
    field Dq6LnSel @0 {
       bits 3;
       access rw;
       reset 3'h6;
    }
  }
  register Dq7LnSel @'ha7 {
    field Dq7LnSel @0 {
       bits 3;
       access rw;
       reset 3'h7;
    }
  }
  register PptCtlStatic @'haa {
    field RFU_PptCtlStatic @0 {
       bits 12;
       access rw;
       reset 12'h0;
    }
  }
  register PptCtlDyn @'hab {
    field RFU_PptCtlDyn @0 {
       bits 2;
       access rw;
       reset 2'h0;
    }
  }
  register PptInfo @'hac {
    field PptInfo @0 {
       bits 16;
       access ro;
       reset 16'h0;
    }
  }
  register PptRxEnEvnt @'had {
    field RFU_PptRxEnEvnt @0 {
       bits 2;
       access rw;
       reset 2'h0;
    }
  }
  register PptDqsCntInvTrnTg0_p0 @'hae {
    field PptDqsCntInvTrnTg0_p0 @0 {
       bits 16;
       access rw;
       reset 16'h0;
    }
  }
  register PptDqsCntInvTrnTg1_p0 @'haf {
    field PptDqsCntInvTrnTg1_p0 @0 {
       bits 16;
       access rw;
       reset 16'h0;
    }
  }
  register DtsmBlankingCtrl @'hb1 {
    field RFU_DtsmBlankingCtrl @0 {
       bits 10;
       access rw;
       reset 10'h0;
    }
  }
  register Tsm0_i0 @'hb2 {
    field RFU_Tsm0_i0 @0 {
       bits 14;
       access rw;
       reset 14'h0;
    }
  }
  register Tsm1_i0 @'hb3 {
    field RFU_Tsm1_i0 @0 {
       bits 16;
       access ro;
       reset 16'h0;
    }
  }
  register Tsm2_i0 @'hb4 {
    field RFU_Tsm2_i0 @0 {
       bits 1;
       access rw;
       reset 1'h0;
    }
  }
  register Tsm3 @'hb5 {
    field RFU_Tsm3 @0 {
       bits 10;
       access rw;
       reset 10'h0;
    }
  }
  register TxChkDataSelects @'hb6 {
    field RFU_TxChkDataSelects @0 {
       bits 2;
       access rw;
       reset 2'h0;
    }
  }
  register DtsmUpThldXingInd @'hb7 {
    field DtsmUpThldXingInd @0 {
       bits 9;
       access ro;
       reset 9'h0;
    }
  }
  register DtsmLoThldXingInd @'hb8 {
    field DtsmLoThldXingInd @0 {
       bits 9;
       access ro;
       reset 9'h0;
    }
  }
  register DbyteAllDtsmCtrl0 @'hb9 {
    field RFU_DbyteAllDtsmCtrl0 @0 {
       bits 9;
       access rw;
       reset 9'h0;
    }
  }
  register DbyteAllDtsmCtrl1 @'hba {
    field RFU_DbyteAllDtsmCtrl1 @0 {
       bits 9;
       access rw;
       reset 9'h0;
    }
  }
  register DbyteAllDtsmCtrl2 @'hbb {
    field RFU_DbyteAllDtsmCtrl2 @0 {
       bits 9;
       access rw;
       reset 9'h0;
    }
  }
  register TxDqDlyTg0_r0_p0 @'hc0 {
    field TxDqDlyTg0_r0_p0 @0 {
       bits 9;
       access rw;
       reset 9'h10;
    }
  }
  register TxDqDlyTg1_r0_p0 @'hc1 {
    field TxDqDlyTg1_r0_p0 @0 {
       bits 9;
       access rw;
       reset 9'h10;
    }
  }
  register TxDqDlyTg2_r0_p0 @'hc2 {
    field TxDqDlyTg2_r0_p0 @0 {
       bits 9;
       access rw;
       reset 9'h10;
    }
  }
  register TxDqDlyTg3_r0_p0 @'hc3 {
    field TxDqDlyTg3_r0_p0 @0 {
       bits 9;
       access rw;
       reset 9'h10;
    }
  }
  register TxDqsDlyTg0_u0_p0 @'hd0 {
    field TxDqsDlyTg0_u0_p0 @0 {
       bits 10;
       access rw;
       reset 10'h100;
    }
  }
  register TxDqsDlyTg1_u0_p0 @'hd1 {
    field TxDqsDlyTg1_u0_p0 @0 {
       bits 10;
       access rw;
       reset 10'h100;
    }
  }
  register TxDqsDlyTg2_u0_p0 @'hd2 {
    field TxDqsDlyTg2_u0_p0 @0 {
       bits 10;
       access rw;
       reset 10'h100;
    }
  }
  register TxDqsDlyTg3_u0_p0 @'hd3 {
    field TxDqsDlyTg3_u0_p0 @0 {
       bits 10;
       access rw;
       reset 10'h100;
    }
  }
  register DxLcdlStatus @'he4 {
    field DxLcdlFineSnapVal @0 {
       bits 10;
       access ro;
       reset 10'h0;
    }
    field DxLcdlPhdSnapVal @10 {
       bits 1;
       access ro;
       reset 1'h0;
    }
    field DxLcdlStickyLock @11 {
       bits 1;
       access ro;
       reset 1'h0;
    }
    field DxLcdlStickyUnlock @12 {
       bits 1;
       access ro;
       reset 1'h0;
    }
    field DxLcdlLiveLock @13 {
       bits 1;
       access ro;
       reset 1'h0;
    }
  }
  register VrefDAC1_r1 @'h130 {
    field VrefDAC1_r1 @0 {
       bits 7;
       access rw;
       reset 7'h0;
    }
  }
  register TrainingCntr_r1 @'h132 {
    field RFU_TrainingCntr_r1 @0 {
       bits 16;
       access rw;
       reset 16'h0;
    }
  }
  register VrefDAC0_r1 @'h140 {
    field VrefDAC0_r1 @0 {
       bits 7;
       access rw;
       reset 7'h0;
    }
  }
  register TxImpedanceCtrl0_b1_p0 @'h141 {
    field DrvStrenDqP @0 {
       bits 6;
       access rw;
       reset 6'h3f;
    }
    field DrvStrenDqN @6 {
       bits 6;
       access rw;
       reset 6'h3f;
    }
  }
  register DqDqsRcvCntrl_b1_p0 @'h143 {
    field SelAnalogVref @0 {
       bits 1;
       access rw;
       reset 1'h0;
    }
    field ExtVrefRange @1 {
       bits 1;
       access rw;
       reset 1'h0;
    }
    field DfeCtrl @2 {
       bits 2;
       access rw;
       reset 2'h0;
    }
    field MajorModeDbyte @4 {
       bits 3;
       access rw;
       reset 3'h3;
    }
    field GainCurrAdj @7 {
       bits 5;
       access rw;
       reset 5'hb;
    }
    field Reserved @12 {
       bits 4;
    }
  }
  register TxImpedanceCtrl1_b1_p0 @'h149 {
    field DrvStrenFSDqP @0 {
       bits 6;
       access rw;
       reset 6'h3f;
    }
    field DrvStrenFSDqN @6 {
       bits 6;
       access rw;
       reset 6'h3f;
    }
  }
  register TxImpedanceCtrl2_b1_p0 @'h14b {
    field DrvStrenEQHiDqP @0 {
       bits 6;
       access rw;
       reset 6'h0;
    }
    field DrvStrenEQLoDqN @6 {
       bits 6;
       access rw;
       reset 6'h0;
    }
  }
  register TxOdtDrvStren_b1_p0 @'h14d {
    field ODTStrenP @0 {
       bits 6;
       access rw;
       reset 6'h0;
    }
    field ODTStrenN @6 {
       bits 6;
       access rw;
       reset 6'h0;
    }
  }
  register TxSlewRate_b1_p0 @'h15f {
    field TxPreP @0 {
       bits 4;
       access rw;
       reset 4'hf;
    }
    field TxPreN @4 {
       bits 4;
       access rw;
       reset 4'hf;
    }
    field TxPreDrvMode @8 {
       bits 3;
       access rw;
       reset 3'h7;
    }
  }
  register TrainingIncDecDtsmEn_r1 @'h162 {
    field TrainingIncDecDtsmEn_r1 @0 {
       bits 9;
       access rw;
       reset 9'h0;
    }
  }
  register RxPBDlyTg0_r1 @'h168 {
    field RxPBDlyTg0_r1 @0 {
       bits 7;
       access rw;
       reset 7'h0;
    }
  }
  register RxPBDlyTg1_r1 @'h169 {
    field RxPBDlyTg1_r1 @0 {
       bits 7;
       access rw;
       reset 7'h0;
    }
  }
  register RxPBDlyTg2_r1 @'h16a {
    field RxPBDlyTg2_r1 @0 {
       bits 7;
       access rw;
       reset 7'h0;
    }
  }
  register RxPBDlyTg3_r1 @'h16b {
    field RxPBDlyTg3_r1 @0 {
       bits 7;
       access rw;
       reset 7'h0;
    }
  }
  register RxEnDlyTg0_u1_p0 @'h180 {
    field RxEnDlyTg0_u1_p0 @0 {
       bits 11;
       access rw;
       reset 11'h100;
    }
  }
  register RxEnDlyTg1_u1_p0 @'h181 {
    field RxEnDlyTg1_u1_p0 @0 {
       bits 11;
       access rw;
       reset 11'h100;
    }
  }
  register RxEnDlyTg2_u1_p0 @'h182 {
    field RxEnDlyTg2_u1_p0 @0 {
       bits 11;
       access rw;
       reset 11'h100;
    }
  }
  register RxEnDlyTg3_u1_p0 @'h183 {
    field RxEnDlyTg3_u1_p0 @0 {
       bits 11;
       access rw;
       reset 11'h100;
    }
  }
  register RxClkDlyTg0_u1_p0 @'h18c {
    field RxClkDlyTg0_u1_p0 @0 {
       bits 6;
       access rw;
       reset 6'h10;
    }
  }
  register RxClkDlyTg1_u1_p0 @'h18d {
    field RxClkDlyTg1_u1_p0 @0 {
       bits 6;
       access rw;
       reset 6'h10;
    }
  }
  register RxClkDlyTg2_u1_p0 @'h18e {
    field RxClkDlyTg2_u1_p0 @0 {
       bits 6;
       access rw;
       reset 6'h10;
    }
  }
  register RxClkDlyTg3_u1_p0 @'h18f {
    field RxClkDlyTg3_u1_p0 @0 {
       bits 6;
       access rw;
       reset 6'h10;
    }
  }
  register RxClkcDlyTg0_u1_p0 @'h190 {
    field RxClkcDlyTg0_u1_p0 @0 {
       bits 6;
       access rw;
       reset 6'h10;
    }
  }
  register RxClkcDlyTg1_u1_p0 @'h191 {
    field RxClkcDlyTg1_u1_p0 @0 {
       bits 6;
       access rw;
       reset 6'h10;
    }
  }
  register RxClkcDlyTg2_u1_p0 @'h192 {
    field RxClkcDlyTg2_u1_p0 @0 {
       bits 6;
       access rw;
       reset 6'h10;
    }
  }
  register RxClkcDlyTg3_u1_p0 @'h193 {
    field RxClkcDlyTg3_u1_p0 @0 {
       bits 6;
       access rw;
       reset 6'h10;
    }
  }
  register Tsm0_i1 @'h1b2 {
    field RFU_Tsm0_i1 @0 {
       bits 14;
       access rw;
       reset 14'h0;
    }
  }
  register Tsm1_i1 @'h1b3 {
    field RFU_Tsm1_i1 @0 {
       bits 16;
       access ro;
       reset 16'h0;
    }
  }
  register Tsm2_i1 @'h1b4 {
    field RFU_Tsm2_i1 @0 {
       bits 1;
       access rw;
       reset 1'h0;
    }
  }
  register TxDqDlyTg0_r1_p0 @'h1c0 {
    field TxDqDlyTg0_r1_p0 @0 {
       bits 9;
       access rw;
       reset 9'h10;
    }
  }
  register TxDqDlyTg1_r1_p0 @'h1c1 {
    field TxDqDlyTg1_r1_p0 @0 {
       bits 9;
       access rw;
       reset 9'h10;
    }
  }
  register TxDqDlyTg2_r1_p0 @'h1c2 {
    field TxDqDlyTg2_r1_p0 @0 {
       bits 9;
       access rw;
       reset 9'h10;
    }
  }
  register TxDqDlyTg3_r1_p0 @'h1c3 {
    field TxDqDlyTg3_r1_p0 @0 {
       bits 9;
       access rw;
       reset 9'h10;
    }
  }
  register TxDqsDlyTg0_u1_p0 @'h1d0 {
    field TxDqsDlyTg0_u1_p0 @0 {
       bits 10;
       access rw;
       reset 10'h100;
    }
  }
  register TxDqsDlyTg1_u1_p0 @'h1d1 {
    field TxDqsDlyTg1_u1_p0 @0 {
       bits 10;
       access rw;
       reset 10'h100;
    }
  }
  register TxDqsDlyTg2_u1_p0 @'h1d2 {
    field TxDqsDlyTg2_u1_p0 @0 {
       bits 10;
       access rw;
       reset 10'h100;
    }
  }
  register TxDqsDlyTg3_u1_p0 @'h1d3 {
    field TxDqsDlyTg3_u1_p0 @0 {
       bits 10;
       access rw;
       reset 10'h100;
    }
  }
  register VrefDAC1_r2 @'h230 {
    field VrefDAC1_r2 @0 {
       bits 7;
       access rw;
       reset 7'h0;
    }
  }
  register TrainingCntr_r2 @'h232 {
    field RFU_TrainingCntr_r2 @0 {
       bits 16;
       access rw;
       reset 16'h0;
    }
  }
  register VrefDAC0_r2 @'h240 {
    field VrefDAC0_r2 @0 {
       bits 7;
       access rw;
       reset 7'h0;
    }
  }
  register TrainingIncDecDtsmEn_r2 @'h262 {
    field TrainingIncDecDtsmEn_r2 @0 {
       bits 9;
       access rw;
       reset 9'h0;
    }
  }
  register RxPBDlyTg0_r2 @'h268 {
    field RxPBDlyTg0_r2 @0 {
       bits 7;
       access rw;
       reset 7'h0;
    }
  }
  register RxPBDlyTg1_r2 @'h269 {
    field RxPBDlyTg1_r2 @0 {
       bits 7;
       access rw;
       reset 7'h0;
    }
  }
  register RxPBDlyTg2_r2 @'h26a {
    field RxPBDlyTg2_r2 @0 {
       bits 7;
       access rw;
       reset 7'h0;
    }
  }
  register RxPBDlyTg3_r2 @'h26b {
    field RxPBDlyTg3_r2 @0 {
       bits 7;
       access rw;
       reset 7'h0;
    }
  }
  register Tsm0_i2 @'h2b2 {
    field RFU_Tsm0_i2 @0 {
       bits 14;
       access rw;
       reset 14'h0;
    }
  }
  register Tsm1_i2 @'h2b3 {
    field RFU_Tsm1_i2 @0 {
       bits 16;
       access ro;
       reset 16'h0;
    }
  }
  register Tsm2_i2 @'h2b4 {
    field RFU_Tsm2_i2 @0 {
       bits 1;
       access rw;
       reset 1'h0;
    }
  }
  register TxDqDlyTg0_r2_p0 @'h2c0 {
    field TxDqDlyTg0_r2_p0 @0 {
       bits 9;
       access rw;
       reset 9'h10;
    }
  }
  register TxDqDlyTg1_r2_p0 @'h2c1 {
    field TxDqDlyTg1_r2_p0 @0 {
       bits 9;
       access rw;
       reset 9'h10;
    }
  }
  register TxDqDlyTg2_r2_p0 @'h2c2 {
    field TxDqDlyTg2_r2_p0 @0 {
       bits 9;
       access rw;
       reset 9'h10;
    }
  }
  register TxDqDlyTg3_r2_p0 @'h2c3 {
    field TxDqDlyTg3_r2_p0 @0 {
       bits 9;
       access rw;
       reset 9'h10;
    }
  }
  register VrefDAC1_r3 @'h330 {
    field VrefDAC1_r3 @0 {
       bits 7;
       access rw;
       reset 7'h0;
    }
  }
  register TrainingCntr_r3 @'h332 {
    field RFU_TrainingCntr_r3 @0 {
       bits 16;
       access rw;
       reset 16'h0;
    }
  }
  register VrefDAC0_r3 @'h340 {
    field VrefDAC0_r3 @0 {
       bits 7;
       access rw;
       reset 7'h0;
    }
  }
  register TrainingIncDecDtsmEn_r3 @'h362 {
    field TrainingIncDecDtsmEn_r3 @0 {
       bits 9;
       access rw;
       reset 9'h0;
    }
  }
  register RxPBDlyTg0_r3 @'h368 {
    field RxPBDlyTg0_r3 @0 {
       bits 7;
       access rw;
       reset 7'h0;
    }
  }
  register RxPBDlyTg1_r3 @'h369 {
    field RxPBDlyTg1_r3 @0 {
       bits 7;
       access rw;
       reset 7'h0;
    }
  }
  register RxPBDlyTg2_r3 @'h36a {
    field RxPBDlyTg2_r3 @0 {
       bits 7;
       access rw;
       reset 7'h0;
    }
  }
  register RxPBDlyTg3_r3 @'h36b {
    field RxPBDlyTg3_r3 @0 {
       bits 7;
       access rw;
       reset 7'h0;
    }
  }
  register Tsm0_i3 @'h3b2 {
    field RFU_Tsm0_i3 @0 {
       bits 14;
       access rw;
       reset 14'h0;
    }
  }
  register Tsm1_i3 @'h3b3 {
    field RFU_Tsm1_i3 @0 {
       bits 16;
       access ro;
       reset 16'h0;
    }
  }
  register Tsm2_i3 @'h3b4 {
    field RFU_Tsm2_i3 @0 {
       bits 1;
       access rw;
       reset 1'h0;
    }
  }
  register TxDqDlyTg0_r3_p0 @'h3c0 {
    field TxDqDlyTg0_r3_p0 @0 {
       bits 9;
       access rw;
       reset 9'h10;
    }
  }
  register TxDqDlyTg1_r3_p0 @'h3c1 {
    field TxDqDlyTg1_r3_p0 @0 {
       bits 9;
       access rw;
       reset 9'h10;
    }
  }
  register TxDqDlyTg2_r3_p0 @'h3c2 {
    field TxDqDlyTg2_r3_p0 @0 {
       bits 9;
       access rw;
       reset 9'h10;
    }
  }
  register TxDqDlyTg3_r3_p0 @'h3c3 {
    field TxDqDlyTg3_r3_p0 @0 {
       bits 9;
       access rw;
       reset 9'h10;
    }
  }
  register VrefDAC1_r4 @'h430 {
    field VrefDAC1_r4 @0 {
       bits 7;
       access rw;
       reset 7'h0;
    }
  }
  register TrainingCntr_r4 @'h432 {
    field RFU_TrainingCntr_r4 @0 {
       bits 16;
       access rw;
       reset 16'h0;
    }
  }
  register VrefDAC0_r4 @'h440 {
    field VrefDAC0_r4 @0 {
       bits 7;
       access rw;
       reset 7'h0;
    }
  }
  register TrainingIncDecDtsmEn_r4 @'h462 {
    field TrainingIncDecDtsmEn_r4 @0 {
       bits 9;
       access rw;
       reset 9'h0;
    }
  }
  register RxPBDlyTg0_r4 @'h468 {
    field RxPBDlyTg0_r4 @0 {
       bits 7;
       access rw;
       reset 7'h0;
    }
  }
  register RxPBDlyTg1_r4 @'h469 {
    field RxPBDlyTg1_r4 @0 {
       bits 7;
       access rw;
       reset 7'h0;
    }
  }
  register RxPBDlyTg2_r4 @'h46a {
    field RxPBDlyTg2_r4 @0 {
       bits 7;
       access rw;
       reset 7'h0;
    }
  }
  register RxPBDlyTg3_r4 @'h46b {
    field RxPBDlyTg3_r4 @0 {
       bits 7;
       access rw;
       reset 7'h0;
    }
  }
  register Tsm0_i4 @'h4b2 {
    field RFU_Tsm0_i4 @0 {
       bits 14;
       access rw;
       reset 14'h0;
    }
  }
  register Tsm1_i4 @'h4b3 {
    field RFU_Tsm1_i4 @0 {
       bits 16;
       access ro;
       reset 16'h0;
    }
  }
  register Tsm2_i4 @'h4b4 {
    field RFU_Tsm2_i4 @0 {
       bits 1;
       access rw;
       reset 1'h0;
    }
  }
  register TxDqDlyTg0_r4_p0 @'h4c0 {
    field TxDqDlyTg0_r4_p0 @0 {
       bits 9;
       access rw;
       reset 9'h10;
    }
  }
  register TxDqDlyTg1_r4_p0 @'h4c1 {
    field TxDqDlyTg1_r4_p0 @0 {
       bits 9;
       access rw;
       reset 9'h10;
    }
  }
  register TxDqDlyTg2_r4_p0 @'h4c2 {
    field TxDqDlyTg2_r4_p0 @0 {
       bits 9;
       access rw;
       reset 9'h10;
    }
  }
  register TxDqDlyTg3_r4_p0 @'h4c3 {
    field TxDqDlyTg3_r4_p0 @0 {
       bits 9;
       access rw;
       reset 9'h10;
    }
  }
  register VrefDAC1_r5 @'h530 {
    field VrefDAC1_r5 @0 {
       bits 7;
       access rw;
       reset 7'h0;
    }
  }
  register TrainingCntr_r5 @'h532 {
    field RFU_TrainingCntr_r5 @0 {
       bits 16;
       access rw;
       reset 16'h0;
    }
  }
  register VrefDAC0_r5 @'h540 {
    field VrefDAC0_r5 @0 {
       bits 7;
       access rw;
       reset 7'h0;
    }
  }
  register TrainingIncDecDtsmEn_r5 @'h562 {
    field TrainingIncDecDtsmEn_r5 @0 {
       bits 9;
       access rw;
       reset 9'h0;
    }
  }
  register RxPBDlyTg0_r5 @'h568 {
    field RxPBDlyTg0_r5 @0 {
       bits 7;
       access rw;
       reset 7'h0;
    }
  }
  register RxPBDlyTg1_r5 @'h569 {
    field RxPBDlyTg1_r5 @0 {
       bits 7;
       access rw;
       reset 7'h0;
    }
  }
  register RxPBDlyTg2_r5 @'h56a {
    field RxPBDlyTg2_r5 @0 {
       bits 7;
       access rw;
       reset 7'h0;
    }
  }
  register RxPBDlyTg3_r5 @'h56b {
    field RxPBDlyTg3_r5 @0 {
       bits 7;
       access rw;
       reset 7'h0;
    }
  }
  register Tsm0_i5 @'h5b2 {
    field RFU_Tsm0_i5 @0 {
       bits 14;
       access rw;
       reset 14'h0;
    }
  }
  register Tsm1_i5 @'h5b3 {
    field RFU_Tsm1_i5 @0 {
       bits 16;
       access ro;
       reset 16'h0;
    }
  }
  register Tsm2_i5 @'h5b4 {
    field RFU_Tsm2_i5 @0 {
       bits 1;
       access rw;
       reset 1'h0;
    }
  }
  register TxDqDlyTg0_r5_p0 @'h5c0 {
    field TxDqDlyTg0_r5_p0 @0 {
       bits 9;
       access rw;
       reset 9'h10;
    }
  }
  register TxDqDlyTg1_r5_p0 @'h5c1 {
    field TxDqDlyTg1_r5_p0 @0 {
       bits 9;
       access rw;
       reset 9'h10;
    }
  }
  register TxDqDlyTg2_r5_p0 @'h5c2 {
    field TxDqDlyTg2_r5_p0 @0 {
       bits 9;
       access rw;
       reset 9'h10;
    }
  }
  register TxDqDlyTg3_r5_p0 @'h5c3 {
    field TxDqDlyTg3_r5_p0 @0 {
       bits 9;
       access rw;
       reset 9'h10;
    }
  }
  register VrefDAC1_r6 @'h630 {
    field VrefDAC1_r6 @0 {
       bits 7;
       access rw;
       reset 7'h0;
    }
  }
  register TrainingCntr_r6 @'h632 {
    field RFU_TrainingCntr_r6 @0 {
       bits 16;
       access rw;
       reset 16'h0;
    }
  }
  register VrefDAC0_r6 @'h640 {
    field VrefDAC0_r6 @0 {
       bits 7;
       access rw;
       reset 7'h0;
    }
  }
  register TrainingIncDecDtsmEn_r6 @'h662 {
    field TrainingIncDecDtsmEn_r6 @0 {
       bits 9;
       access rw;
       reset 9'h0;
    }
  }
  register RxPBDlyTg0_r6 @'h668 {
    field RxPBDlyTg0_r6 @0 {
       bits 7;
       access rw;
       reset 7'h0;
    }
  }
  register RxPBDlyTg1_r6 @'h669 {
    field RxPBDlyTg1_r6 @0 {
       bits 7;
       access rw;
       reset 7'h0;
    }
  }
  register RxPBDlyTg2_r6 @'h66a {
    field RxPBDlyTg2_r6 @0 {
       bits 7;
       access rw;
       reset 7'h0;
    }
  }
  register RxPBDlyTg3_r6 @'h66b {
    field RxPBDlyTg3_r6 @0 {
       bits 7;
       access rw;
       reset 7'h0;
    }
  }
  register Tsm0_i6 @'h6b2 {
    field RFU_Tsm0_i6 @0 {
       bits 14;
       access rw;
       reset 14'h0;
    }
  }
  register Tsm1_i6 @'h6b3 {
    field RFU_Tsm1_i6 @0 {
       bits 16;
       access ro;
       reset 16'h0;
    }
  }
  register Tsm2_i6 @'h6b4 {
    field RFU_Tsm2_i6 @0 {
       bits 1;
       access rw;
       reset 1'h0;
    }
  }
  register TxDqDlyTg0_r6_p0 @'h6c0 {
    field TxDqDlyTg0_r6_p0 @0 {
       bits 9;
       access rw;
       reset 9'h10;
    }
  }
  register TxDqDlyTg1_r6_p0 @'h6c1 {
    field TxDqDlyTg1_r6_p0 @0 {
       bits 9;
       access rw;
       reset 9'h10;
    }
  }
  register TxDqDlyTg2_r6_p0 @'h6c2 {
    field TxDqDlyTg2_r6_p0 @0 {
       bits 9;
       access rw;
       reset 9'h10;
    }
  }
  register TxDqDlyTg3_r6_p0 @'h6c3 {
    field TxDqDlyTg3_r6_p0 @0 {
       bits 9;
       access rw;
       reset 9'h10;
    }
  }
  register VrefDAC1_r7 @'h730 {
    field VrefDAC1_r7 @0 {
       bits 7;
       access rw;
       reset 7'h0;
    }
  }
  register TrainingCntr_r7 @'h732 {
    field RFU_TrainingCntr_r7 @0 {
       bits 16;
       access rw;
       reset 16'h0;
    }
  }
  register VrefDAC0_r7 @'h740 {
    field VrefDAC0_r7 @0 {
       bits 7;
       access rw;
       reset 7'h0;
    }
  }
  register TrainingIncDecDtsmEn_r7 @'h762 {
    field TrainingIncDecDtsmEn_r7 @0 {
       bits 9;
       access rw;
       reset 9'h0;
    }
  }
  register RxPBDlyTg0_r7 @'h768 {
    field RxPBDlyTg0_r7 @0 {
       bits 7;
       access rw;
       reset 7'h0;
    }
  }
  register RxPBDlyTg1_r7 @'h769 {
    field RxPBDlyTg1_r7 @0 {
       bits 7;
       access rw;
       reset 7'h0;
    }
  }
  register RxPBDlyTg2_r7 @'h76a {
    field RxPBDlyTg2_r7 @0 {
       bits 7;
       access rw;
       reset 7'h0;
    }
  }
  register RxPBDlyTg3_r7 @'h76b {
    field RxPBDlyTg3_r7 @0 {
       bits 7;
       access rw;
       reset 7'h0;
    }
  }
  register Tsm0_i7 @'h7b2 {
    field RFU_Tsm0_i7 @0 {
       bits 14;
       access rw;
       reset 14'h0;
    }
  }
  register Tsm1_i7 @'h7b3 {
    field RFU_Tsm1_i7 @0 {
       bits 16;
       access ro;
       reset 16'h0;
    }
  }
  register Tsm2_i7 @'h7b4 {
    field RFU_Tsm2_i7 @0 {
       bits 1;
       access rw;
       reset 1'h0;
    }
  }
  register TxDqDlyTg0_r7_p0 @'h7c0 {
    field TxDqDlyTg0_r7_p0 @0 {
       bits 9;
       access rw;
       reset 9'h10;
    }
  }
  register TxDqDlyTg1_r7_p0 @'h7c1 {
    field TxDqDlyTg1_r7_p0 @0 {
       bits 9;
       access rw;
       reset 9'h10;
    }
  }
  register TxDqDlyTg2_r7_p0 @'h7c2 {
    field TxDqDlyTg2_r7_p0 @0 {
       bits 9;
       access rw;
       reset 9'h10;
    }
  }
  register TxDqDlyTg3_r7_p0 @'h7c3 {
    field TxDqDlyTg3_r7_p0 @0 {
       bits 9;
       access rw;
       reset 9'h10;
    }
  }
  register VrefDAC1_r8 @'h830 {
    field VrefDAC1_r8 @0 {
       bits 7;
       access rw;
       reset 7'h0;
    }
  }
  register TrainingCntr_r8 @'h832 {
    field RFU_TrainingCntr_r8 @0 {
       bits 16;
       access rw;
       reset 16'h0;
    }
  }
  register VrefDAC0_r8 @'h840 {
    field VrefDAC0_r8 @0 {
       bits 7;
       access rw;
       reset 7'h0;
    }
  }
  register TrainingIncDecDtsmEn_r8 @'h862 {
    field TrainingIncDecDtsmEn_r8 @0 {
       bits 9;
       access rw;
       reset 9'h0;
    }
  }
  register RxPBDlyTg0_r8 @'h868 {
    field RxPBDlyTg0_r8 @0 {
       bits 7;
       access rw;
       reset 7'h0;
    }
  }
  register RxPBDlyTg1_r8 @'h869 {
    field RxPBDlyTg1_r8 @0 {
       bits 7;
       access rw;
       reset 7'h0;
    }
  }
  register RxPBDlyTg2_r8 @'h86a {
    field RxPBDlyTg2_r8 @0 {
       bits 7;
       access rw;
       reset 7'h0;
    }
  }
  register RxPBDlyTg3_r8 @'h86b {
    field RxPBDlyTg3_r8 @0 {
       bits 7;
       access rw;
       reset 7'h0;
    }
  }
  register Tsm0_i8 @'h8b2 {
    field RFU_Tsm0_i8 @0 {
       bits 14;
       access rw;
       reset 14'h0;
    }
  }
  register Tsm1_i8 @'h8b3 {
    field RFU_Tsm1_i8 @0 {
       bits 16;
       access ro;
       reset 16'h0;
    }
  }
  register Tsm2_i8 @'h8b4 {
    field RFU_Tsm2_i8 @0 {
       bits 1;
       access rw;
       reset 1'h0;
    }
  }
  register TxDqDlyTg0_r8_p0 @'h8c0 {
    field TxDqDlyTg0_r8_p0 @0 {
       bits 9;
       access rw;
       reset 9'h10;
    }
  }
  register TxDqDlyTg1_r8_p0 @'h8c1 {
    field TxDqDlyTg1_r8_p0 @0 {
       bits 9;
       access rw;
       reset 9'h10;
    }
  }
  register TxDqDlyTg2_r8_p0 @'h8c2 {
    field TxDqDlyTg2_r8_p0 @0 {
       bits 9;
       access rw;
       reset 9'h10;
    }
  }
  register TxDqDlyTg3_r8_p0 @'h8c3 {
    field TxDqDlyTg3_r8_p0 @0 {
       bits 9;
       access rw;
       reset 9'h10;
    }
  }
  register UseDqsEnReplica_p1 @'h100003 {
    field UseDqsEnReplica_p1 @0 {
       bits 1;
       access rw;
       reset 1'h0;
    }
  }
  register DFIMRL_p1 @'h100020 {
    field DFIMRL_p1 @0 {
       bits 5;
       access rw;
       reset 5'h6;
    }
  }
  register TxImpedanceCtrl0_b0_p1 @'h100041 {
    field DrvStrenDqP @0 {
       bits 6;
       access rw;
       reset 6'h3f;
    }
    field DrvStrenDqN @6 {
       bits 6;
       access rw;
       reset 6'h3f;
    }
  }
  register DqDqsRcvCntrl_b0_p1 @'h100043 {
    field SelAnalogVref @0 {
       bits 1;
       access rw;
       reset 1'h0;
    }
    field ExtVrefRange @1 {
       bits 1;
       access rw;
       reset 1'h0;
    }
    field DfeCtrl @2 {
       bits 2;
       access rw;
       reset 2'h0;
    }
    field MajorModeDbyte @4 {
       bits 3;
       access rw;
       reset 3'h3;
    }
    field GainCurrAdj @7 {
       bits 5;
       access rw;
       reset 5'hb;
    }
    field Reserved @12 {
       bits 4;
    }
  }
  register TxEqualizationMode_p1 @'h100048 {
    field TxEqMode @0 {
       bits 2;
       access rw;
       reset 2'h0;
    }
  }
  register TxImpedanceCtrl1_b0_p1 @'h100049 {
    field DrvStrenFSDqP @0 {
       bits 6;
       access rw;
       reset 6'h3f;
    }
    field DrvStrenFSDqN @6 {
       bits 6;
       access rw;
       reset 6'h3f;
    }
  }
  register TxImpedanceCtrl2_b0_p1 @'h10004b {
    field DrvStrenEQHiDqP @0 {
       bits 6;
       access rw;
       reset 6'h0;
    }
    field DrvStrenEQLoDqN @6 {
       bits 6;
       access rw;
       reset 6'h0;
    }
  }
  register DqDqsRcvCntrl2_p1 @'h10004c {
    field EnRxAgressivePDR @0 {
       bits 1;
       access rw;
       reset 1'h0;
    }
  }
  register TxOdtDrvStren_b0_p1 @'h10004d {
    field ODTStrenP @0 {
       bits 6;
       access rw;
       reset 6'h0;
    }
    field ODTStrenN @6 {
       bits 6;
       access rw;
       reset 6'h0;
    }
  }
  register TxSlewRate_b0_p1 @'h10005f {
    field TxPreP @0 {
       bits 4;
       access rw;
       reset 4'hf;
    }
    field TxPreN @4 {
       bits 4;
       access rw;
       reset 4'hf;
    }
    field TxPreDrvMode @8 {
       bits 3;
       access rw;
       reset 3'h7;
    }
  }
  register RxEnDlyTg0_u0_p1 @'h100080 {
    field RxEnDlyTg0_u0_p1 @0 {
       bits 11;
       access rw;
       reset 11'h100;
    }
  }
  register RxEnDlyTg1_u0_p1 @'h100081 {
    field RxEnDlyTg1_u0_p1 @0 {
       bits 11;
       access rw;
       reset 11'h100;
    }
  }
  register RxEnDlyTg2_u0_p1 @'h100082 {
    field RxEnDlyTg2_u0_p1 @0 {
       bits 11;
       access rw;
       reset 11'h100;
    }
  }
  register RxEnDlyTg3_u0_p1 @'h100083 {
    field RxEnDlyTg3_u0_p1 @0 {
       bits 11;
       access rw;
       reset 11'h100;
    }
  }
  register RxClkDlyTg0_u0_p1 @'h10008c {
    field RxClkDlyTg0_u0_p1 @0 {
       bits 6;
       access rw;
       reset 6'h10;
    }
  }
  register RxClkDlyTg1_u0_p1 @'h10008d {
    field RxClkDlyTg1_u0_p1 @0 {
       bits 6;
       access rw;
       reset 6'h10;
    }
  }
  register RxClkDlyTg2_u0_p1 @'h10008e {
    field RxClkDlyTg2_u0_p1 @0 {
       bits 6;
       access rw;
       reset 6'h10;
    }
  }
  register RxClkDlyTg3_u0_p1 @'h10008f {
    field RxClkDlyTg3_u0_p1 @0 {
       bits 6;
       access rw;
       reset 6'h10;
    }
  }
  register RxClkcDlyTg0_u0_p1 @'h100090 {
    field RxClkcDlyTg0_u0_p1 @0 {
       bits 6;
       access rw;
       reset 6'h10;
    }
  }
  register RxClkcDlyTg1_u0_p1 @'h100091 {
    field RxClkcDlyTg1_u0_p1 @0 {
       bits 6;
       access rw;
       reset 6'h10;
    }
  }
  register RxClkcDlyTg2_u0_p1 @'h100092 {
    field RxClkcDlyTg2_u0_p1 @0 {
       bits 6;
       access rw;
       reset 6'h10;
    }
  }
  register RxClkcDlyTg3_u0_p1 @'h100093 {
    field RxClkcDlyTg3_u0_p1 @0 {
       bits 6;
       access rw;
       reset 6'h10;
    }
  }
  register PptDqsCntInvTrnTg0_p1 @'h1000ae {
    field PptDqsCntInvTrnTg0_p1 @0 {
       bits 16;
       access rw;
       reset 16'h0;
    }
  }
  register PptDqsCntInvTrnTg1_p1 @'h1000af {
    field PptDqsCntInvTrnTg1_p1 @0 {
       bits 16;
       access rw;
       reset 16'h0;
    }
  }
  register TxDqDlyTg0_r0_p1 @'h1000c0 {
    field TxDqDlyTg0_r0_p1 @0 {
       bits 9;
       access rw;
       reset 9'h10;
    }
  }
  register TxDqDlyTg1_r0_p1 @'h1000c1 {
    field TxDqDlyTg1_r0_p1 @0 {
       bits 9;
       access rw;
       reset 9'h10;
    }
  }
  register TxDqDlyTg2_r0_p1 @'h1000c2 {
    field TxDqDlyTg2_r0_p1 @0 {
       bits 9;
       access rw;
       reset 9'h10;
    }
  }
  register TxDqDlyTg3_r0_p1 @'h1000c3 {
    field TxDqDlyTg3_r0_p1 @0 {
       bits 9;
       access rw;
       reset 9'h10;
    }
  }
  register TxDqsDlyTg0_u0_p1 @'h1000d0 {
    field TxDqsDlyTg0_u0_p1 @0 {
       bits 10;
       access rw;
       reset 10'h100;
    }
  }
  register TxDqsDlyTg1_u0_p1 @'h1000d1 {
    field TxDqsDlyTg1_u0_p1 @0 {
       bits 10;
       access rw;
       reset 10'h100;
    }
  }
  register TxDqsDlyTg2_u0_p1 @'h1000d2 {
    field TxDqsDlyTg2_u0_p1 @0 {
       bits 10;
       access rw;
       reset 10'h100;
    }
  }
  register TxDqsDlyTg3_u0_p1 @'h1000d3 {
    field TxDqsDlyTg3_u0_p1 @0 {
       bits 10;
       access rw;
       reset 10'h100;
    }
  }
  register TxImpedanceCtrl0_b1_p1 @'h100141 {
    field DrvStrenDqP @0 {
       bits 6;
       access rw;
       reset 6'h3f;
    }
    field DrvStrenDqN @6 {
       bits 6;
       access rw;
       reset 6'h3f;
    }
  }
  register DqDqsRcvCntrl_b1_p1 @'h100143 {
    field SelAnalogVref @0 {
       bits 1;
       access rw;
       reset 1'h0;
    }
    field ExtVrefRange @1 {
       bits 1;
       access rw;
       reset 1'h0;
    }
    field DfeCtrl @2 {
       bits 2;
       access rw;
       reset 2'h0;
    }
    field MajorModeDbyte @4 {
       bits 3;
       access rw;
       reset 3'h3;
    }
    field GainCurrAdj @7 {
       bits 5;
       access rw;
       reset 5'hb;
    }
    field Reserved @12 {
       bits 4;
    }
  }
  register TxImpedanceCtrl1_b1_p1 @'h100149 {
    field DrvStrenFSDqP @0 {
       bits 6;
       access rw;
       reset 6'h3f;
    }
    field DrvStrenFSDqN @6 {
       bits 6;
       access rw;
       reset 6'h3f;
    }
  }
  register TxImpedanceCtrl2_b1_p1 @'h10014b {
    field DrvStrenEQHiDqP @0 {
       bits 6;
       access rw;
       reset 6'h0;
    }
    field DrvStrenEQLoDqN @6 {
       bits 6;
       access rw;
       reset 6'h0;
    }
  }
  register TxOdtDrvStren_b1_p1 @'h10014d {
    field ODTStrenP @0 {
       bits 6;
       access rw;
       reset 6'h0;
    }
    field ODTStrenN @6 {
       bits 6;
       access rw;
       reset 6'h0;
    }
  }
  register TxSlewRate_b1_p1 @'h10015f {
    field TxPreP @0 {
       bits 4;
       access rw;
       reset 4'hf;
    }
    field TxPreN @4 {
       bits 4;
       access rw;
       reset 4'hf;
    }
    field TxPreDrvMode @8 {
       bits 3;
       access rw;
       reset 3'h7;
    }
  }
  register RxEnDlyTg0_u1_p1 @'h100180 {
    field RxEnDlyTg0_u1_p1 @0 {
       bits 11;
       access rw;
       reset 11'h100;
    }
  }
  register RxEnDlyTg1_u1_p1 @'h100181 {
    field RxEnDlyTg1_u1_p1 @0 {
       bits 11;
       access rw;
       reset 11'h100;
    }
  }
  register RxEnDlyTg2_u1_p1 @'h100182 {
    field RxEnDlyTg2_u1_p1 @0 {
       bits 11;
       access rw;
       reset 11'h100;
    }
  }
  register RxEnDlyTg3_u1_p1 @'h100183 {
    field RxEnDlyTg3_u1_p1 @0 {
       bits 11;
       access rw;
       reset 11'h100;
    }
  }
  register RxClkDlyTg0_u1_p1 @'h10018c {
    field RxClkDlyTg0_u1_p1 @0 {
       bits 6;
       access rw;
       reset 6'h10;
    }
  }
  register RxClkDlyTg1_u1_p1 @'h10018d {
    field RxClkDlyTg1_u1_p1 @0 {
       bits 6;
       access rw;
       reset 6'h10;
    }
  }
  register RxClkDlyTg2_u1_p1 @'h10018e {
    field RxClkDlyTg2_u1_p1 @0 {
       bits 6;
       access rw;
       reset 6'h10;
    }
  }
  register RxClkDlyTg3_u1_p1 @'h10018f {
    field RxClkDlyTg3_u1_p1 @0 {
       bits 6;
       access rw;
       reset 6'h10;
    }
  }
  register RxClkcDlyTg0_u1_p1 @'h100190 {
    field RxClkcDlyTg0_u1_p1 @0 {
       bits 6;
       access rw;
       reset 6'h10;
    }
  }
  register RxClkcDlyTg1_u1_p1 @'h100191 {
    field RxClkcDlyTg1_u1_p1 @0 {
       bits 6;
       access rw;
       reset 6'h10;
    }
  }
  register RxClkcDlyTg2_u1_p1 @'h100192 {
    field RxClkcDlyTg2_u1_p1 @0 {
       bits 6;
       access rw;
       reset 6'h10;
    }
  }
  register RxClkcDlyTg3_u1_p1 @'h100193 {
    field RxClkcDlyTg3_u1_p1 @0 {
       bits 6;
       access rw;
       reset 6'h10;
    }
  }
  register TxDqDlyTg0_r1_p1 @'h1001c0 {
    field TxDqDlyTg0_r1_p1 @0 {
       bits 9;
       access rw;
       reset 9'h10;
    }
  }
  register TxDqDlyTg1_r1_p1 @'h1001c1 {
    field TxDqDlyTg1_r1_p1 @0 {
       bits 9;
       access rw;
       reset 9'h10;
    }
  }
  register TxDqDlyTg2_r1_p1 @'h1001c2 {
    field TxDqDlyTg2_r1_p1 @0 {
       bits 9;
       access rw;
       reset 9'h10;
    }
  }
  register TxDqDlyTg3_r1_p1 @'h1001c3 {
    field TxDqDlyTg3_r1_p1 @0 {
       bits 9;
       access rw;
       reset 9'h10;
    }
  }
  register TxDqsDlyTg0_u1_p1 @'h1001d0 {
    field TxDqsDlyTg0_u1_p1 @0 {
       bits 10;
       access rw;
       reset 10'h100;
    }
  }
  register TxDqsDlyTg1_u1_p1 @'h1001d1 {
    field TxDqsDlyTg1_u1_p1 @0 {
       bits 10;
       access rw;
       reset 10'h100;
    }
  }
  register TxDqsDlyTg2_u1_p1 @'h1001d2 {
    field TxDqsDlyTg2_u1_p1 @0 {
       bits 10;
       access rw;
       reset 10'h100;
    }
  }
  register TxDqsDlyTg3_u1_p1 @'h1001d3 {
    field TxDqsDlyTg3_u1_p1 @0 {
       bits 10;
       access rw;
       reset 10'h100;
    }
  }
  register TxDqDlyTg0_r2_p1 @'h1002c0 {
    field TxDqDlyTg0_r2_p1 @0 {
       bits 9;
       access rw;
       reset 9'h10;
    }
  }
  register TxDqDlyTg1_r2_p1 @'h1002c1 {
    field TxDqDlyTg1_r2_p1 @0 {
       bits 9;
       access rw;
       reset 9'h10;
    }
  }
  register TxDqDlyTg2_r2_p1 @'h1002c2 {
    field TxDqDlyTg2_r2_p1 @0 {
       bits 9;
       access rw;
       reset 9'h10;
    }
  }
  register TxDqDlyTg3_r2_p1 @'h1002c3 {
    field TxDqDlyTg3_r2_p1 @0 {
       bits 9;
       access rw;
       reset 9'h10;
    }
  }
  register TxDqDlyTg0_r3_p1 @'h1003c0 {
    field TxDqDlyTg0_r3_p1 @0 {
       bits 9;
       access rw;
       reset 9'h10;
    }
  }
  register TxDqDlyTg1_r3_p1 @'h1003c1 {
    field TxDqDlyTg1_r3_p1 @0 {
       bits 9;
       access rw;
       reset 9'h10;
    }
  }
  register TxDqDlyTg2_r3_p1 @'h1003c2 {
    field TxDqDlyTg2_r3_p1 @0 {
       bits 9;
       access rw;
       reset 9'h10;
    }
  }
  register TxDqDlyTg3_r3_p1 @'h1003c3 {
    field TxDqDlyTg3_r3_p1 @0 {
       bits 9;
       access rw;
       reset 9'h10;
    }
  }
  register TxDqDlyTg0_r4_p1 @'h1004c0 {
    field TxDqDlyTg0_r4_p1 @0 {
       bits 9;
       access rw;
       reset 9'h10;
    }
  }
  register TxDqDlyTg1_r4_p1 @'h1004c1 {
    field TxDqDlyTg1_r4_p1 @0 {
       bits 9;
       access rw;
       reset 9'h10;
    }
  }
  register TxDqDlyTg2_r4_p1 @'h1004c2 {
    field TxDqDlyTg2_r4_p1 @0 {
       bits 9;
       access rw;
       reset 9'h10;
    }
  }
  register TxDqDlyTg3_r4_p1 @'h1004c3 {
    field TxDqDlyTg3_r4_p1 @0 {
       bits 9;
       access rw;
       reset 9'h10;
    }
  }
  register TxDqDlyTg0_r5_p1 @'h1005c0 {
    field TxDqDlyTg0_r5_p1 @0 {
       bits 9;
       access rw;
       reset 9'h10;
    }
  }
  register TxDqDlyTg1_r5_p1 @'h1005c1 {
    field TxDqDlyTg1_r5_p1 @0 {
       bits 9;
       access rw;
       reset 9'h10;
    }
  }
  register TxDqDlyTg2_r5_p1 @'h1005c2 {
    field TxDqDlyTg2_r5_p1 @0 {
       bits 9;
       access rw;
       reset 9'h10;
    }
  }
  register TxDqDlyTg3_r5_p1 @'h1005c3 {
    field TxDqDlyTg3_r5_p1 @0 {
       bits 9;
       access rw;
       reset 9'h10;
    }
  }
  register TxDqDlyTg0_r6_p1 @'h1006c0 {
    field TxDqDlyTg0_r6_p1 @0 {
       bits 9;
       access rw;
       reset 9'h10;
    }
  }
  register TxDqDlyTg1_r6_p1 @'h1006c1 {
    field TxDqDlyTg1_r6_p1 @0 {
       bits 9;
       access rw;
       reset 9'h10;
    }
  }
  register TxDqDlyTg2_r6_p1 @'h1006c2 {
    field TxDqDlyTg2_r6_p1 @0 {
       bits 9;
       access rw;
       reset 9'h10;
    }
  }
  register TxDqDlyTg3_r6_p1 @'h1006c3 {
    field TxDqDlyTg3_r6_p1 @0 {
       bits 9;
       access rw;
       reset 9'h10;
    }
  }
  register TxDqDlyTg0_r7_p1 @'h1007c0 {
    field TxDqDlyTg0_r7_p1 @0 {
       bits 9;
       access rw;
       reset 9'h10;
    }
  }
  register TxDqDlyTg1_r7_p1 @'h1007c1 {
    field TxDqDlyTg1_r7_p1 @0 {
       bits 9;
       access rw;
       reset 9'h10;
    }
  }
  register TxDqDlyTg2_r7_p1 @'h1007c2 {
    field TxDqDlyTg2_r7_p1 @0 {
       bits 9;
       access rw;
       reset 9'h10;
    }
  }
  register TxDqDlyTg3_r7_p1 @'h1007c3 {
    field TxDqDlyTg3_r7_p1 @0 {
       bits 9;
       access rw;
       reset 9'h10;
    }
  }
  register TxDqDlyTg0_r8_p1 @'h1008c0 {
    field TxDqDlyTg0_r8_p1 @0 {
       bits 9;
       access rw;
       reset 9'h10;
    }
  }
  register TxDqDlyTg1_r8_p1 @'h1008c1 {
    field TxDqDlyTg1_r8_p1 @0 {
       bits 9;
       access rw;
       reset 9'h10;
    }
  }
  register TxDqDlyTg2_r8_p1 @'h1008c2 {
    field TxDqDlyTg2_r8_p1 @0 {
       bits 9;
       access rw;
       reset 9'h10;
    }
  }
  register TxDqDlyTg3_r8_p1 @'h1008c3 {
    field TxDqDlyTg3_r8_p1 @0 {
       bits 9;
       access rw;
       reset 9'h10;
    }
  }
  register UseDqsEnReplica_p2 @'h200003 {
    field UseDqsEnReplica_p2 @0 {
       bits 1;
       access rw;
       reset 1'h0;
    }
  }
  register DFIMRL_p2 @'h200020 {
    field DFIMRL_p2 @0 {
       bits 5;
       access rw;
       reset 5'h6;
    }
  }
  register TxImpedanceCtrl0_b0_p2 @'h200041 {
    field DrvStrenDqP @0 {
       bits 6;
       access rw;
       reset 6'h3f;
    }
    field DrvStrenDqN @6 {
       bits 6;
       access rw;
       reset 6'h3f;
    }
  }
  register DqDqsRcvCntrl_b0_p2 @'h200043 {
    field SelAnalogVref @0 {
       bits 1;
       access rw;
       reset 1'h0;
    }
    field ExtVrefRange @1 {
       bits 1;
       access rw;
       reset 1'h0;
    }
    field DfeCtrl @2 {
       bits 2;
       access rw;
       reset 2'h0;
    }
    field MajorModeDbyte @4 {
       bits 3;
       access rw;
       reset 3'h3;
    }
    field GainCurrAdj @7 {
       bits 5;
       access rw;
       reset 5'hb;
    }
    field Reserved @12 {
       bits 4;
    }
  }
  register TxEqualizationMode_p2 @'h200048 {
    field TxEqMode @0 {
       bits 2;
       access rw;
       reset 2'h0;
    }
  }
  register TxImpedanceCtrl1_b0_p2 @'h200049 {
    field DrvStrenFSDqP @0 {
       bits 6;
       access rw;
       reset 6'h3f;
    }
    field DrvStrenFSDqN @6 {
       bits 6;
       access rw;
       reset 6'h3f;
    }
  }
  register TxImpedanceCtrl2_b0_p2 @'h20004b {
    field DrvStrenEQHiDqP @0 {
       bits 6;
       access rw;
       reset 6'h0;
    }
    field DrvStrenEQLoDqN @6 {
       bits 6;
       access rw;
       reset 6'h0;
    }
  }
  register DqDqsRcvCntrl2_p2 @'h20004c {
    field EnRxAgressivePDR @0 {
       bits 1;
       access rw;
       reset 1'h0;
    }
  }
  register TxOdtDrvStren_b0_p2 @'h20004d {
    field ODTStrenP @0 {
       bits 6;
       access rw;
       reset 6'h0;
    }
    field ODTStrenN @6 {
       bits 6;
       access rw;
       reset 6'h0;
    }
  }
  register TxSlewRate_b0_p2 @'h20005f {
    field TxPreP @0 {
       bits 4;
       access rw;
       reset 4'hf;
    }
    field TxPreN @4 {
       bits 4;
       access rw;
       reset 4'hf;
    }
    field TxPreDrvMode @8 {
       bits 3;
       access rw;
       reset 3'h7;
    }
  }
  register RxEnDlyTg0_u0_p2 @'h200080 {
    field RxEnDlyTg0_u0_p2 @0 {
       bits 11;
       access rw;
       reset 11'h100;
    }
  }
  register RxEnDlyTg1_u0_p2 @'h200081 {
    field RxEnDlyTg1_u0_p2 @0 {
       bits 11;
       access rw;
       reset 11'h100;
    }
  }
  register RxEnDlyTg2_u0_p2 @'h200082 {
    field RxEnDlyTg2_u0_p2 @0 {
       bits 11;
       access rw;
       reset 11'h100;
    }
  }
  register RxEnDlyTg3_u0_p2 @'h200083 {
    field RxEnDlyTg3_u0_p2 @0 {
       bits 11;
       access rw;
       reset 11'h100;
    }
  }
  register RxClkDlyTg0_u0_p2 @'h20008c {
    field RxClkDlyTg0_u0_p2 @0 {
       bits 6;
       access rw;
       reset 6'h10;
    }
  }
  register RxClkDlyTg1_u0_p2 @'h20008d {
    field RxClkDlyTg1_u0_p2 @0 {
       bits 6;
       access rw;
       reset 6'h10;
    }
  }
  register RxClkDlyTg2_u0_p2 @'h20008e {
    field RxClkDlyTg2_u0_p2 @0 {
       bits 6;
       access rw;
       reset 6'h10;
    }
  }
  register RxClkDlyTg3_u0_p2 @'h20008f {
    field RxClkDlyTg3_u0_p2 @0 {
       bits 6;
       access rw;
       reset 6'h10;
    }
  }
  register RxClkcDlyTg0_u0_p2 @'h200090 {
    field RxClkcDlyTg0_u0_p2 @0 {
       bits 6;
       access rw;
       reset 6'h10;
    }
  }
  register RxClkcDlyTg1_u0_p2 @'h200091 {
    field RxClkcDlyTg1_u0_p2 @0 {
       bits 6;
       access rw;
       reset 6'h10;
    }
  }
  register RxClkcDlyTg2_u0_p2 @'h200092 {
    field RxClkcDlyTg2_u0_p2 @0 {
       bits 6;
       access rw;
       reset 6'h10;
    }
  }
  register RxClkcDlyTg3_u0_p2 @'h200093 {
    field RxClkcDlyTg3_u0_p2 @0 {
       bits 6;
       access rw;
       reset 6'h10;
    }
  }
  register PptDqsCntInvTrnTg0_p2 @'h2000ae {
    field PptDqsCntInvTrnTg0_p2 @0 {
       bits 16;
       access rw;
       reset 16'h0;
    }
  }
  register PptDqsCntInvTrnTg1_p2 @'h2000af {
    field PptDqsCntInvTrnTg1_p2 @0 {
       bits 16;
       access rw;
       reset 16'h0;
    }
  }
  register TxDqDlyTg0_r0_p2 @'h2000c0 {
    field TxDqDlyTg0_r0_p2 @0 {
       bits 9;
       access rw;
       reset 9'h10;
    }
  }
  register TxDqDlyTg1_r0_p2 @'h2000c1 {
    field TxDqDlyTg1_r0_p2 @0 {
       bits 9;
       access rw;
       reset 9'h10;
    }
  }
  register TxDqDlyTg2_r0_p2 @'h2000c2 {
    field TxDqDlyTg2_r0_p2 @0 {
       bits 9;
       access rw;
       reset 9'h10;
    }
  }
  register TxDqDlyTg3_r0_p2 @'h2000c3 {
    field TxDqDlyTg3_r0_p2 @0 {
       bits 9;
       access rw;
       reset 9'h10;
    }
  }
  register TxDqsDlyTg0_u0_p2 @'h2000d0 {
    field TxDqsDlyTg0_u0_p2 @0 {
       bits 10;
       access rw;
       reset 10'h100;
    }
  }
  register TxDqsDlyTg1_u0_p2 @'h2000d1 {
    field TxDqsDlyTg1_u0_p2 @0 {
       bits 10;
       access rw;
       reset 10'h100;
    }
  }
  register TxDqsDlyTg2_u0_p2 @'h2000d2 {
    field TxDqsDlyTg2_u0_p2 @0 {
       bits 10;
       access rw;
       reset 10'h100;
    }
  }
  register TxDqsDlyTg3_u0_p2 @'h2000d3 {
    field TxDqsDlyTg3_u0_p2 @0 {
       bits 10;
       access rw;
       reset 10'h100;
    }
  }
  register TxImpedanceCtrl0_b1_p2 @'h200141 {
    field DrvStrenDqP @0 {
       bits 6;
       access rw;
       reset 6'h3f;
    }
    field DrvStrenDqN @6 {
       bits 6;
       access rw;
       reset 6'h3f;
    }
  }
  register DqDqsRcvCntrl_b1_p2 @'h200143 {
    field SelAnalogVref @0 {
       bits 1;
       access rw;
       reset 1'h0;
    }
    field ExtVrefRange @1 {
       bits 1;
       access rw;
       reset 1'h0;
    }
    field DfeCtrl @2 {
       bits 2;
       access rw;
       reset 2'h0;
    }
    field MajorModeDbyte @4 {
       bits 3;
       access rw;
       reset 3'h3;
    }
    field GainCurrAdj @7 {
       bits 5;
       access rw;
       reset 5'hb;
    }
    field Reserved @12 {
       bits 4;
    }
  }
  register TxImpedanceCtrl1_b1_p2 @'h200149 {
    field DrvStrenFSDqP @0 {
       bits 6;
       access rw;
       reset 6'h3f;
    }
    field DrvStrenFSDqN @6 {
       bits 6;
       access rw;
       reset 6'h3f;
    }
  }
  register TxImpedanceCtrl2_b1_p2 @'h20014b {
    field DrvStrenEQHiDqP @0 {
       bits 6;
       access rw;
       reset 6'h0;
    }
    field DrvStrenEQLoDqN @6 {
       bits 6;
       access rw;
       reset 6'h0;
    }
  }
  register TxOdtDrvStren_b1_p2 @'h20014d {
    field ODTStrenP @0 {
       bits 6;
       access rw;
       reset 6'h0;
    }
    field ODTStrenN @6 {
       bits 6;
       access rw;
       reset 6'h0;
    }
  }
  register TxSlewRate_b1_p2 @'h20015f {
    field TxPreP @0 {
       bits 4;
       access rw;
       reset 4'hf;
    }
    field TxPreN @4 {
       bits 4;
       access rw;
       reset 4'hf;
    }
    field TxPreDrvMode @8 {
       bits 3;
       access rw;
       reset 3'h7;
    }
  }
  register RxEnDlyTg0_u1_p2 @'h200180 {
    field RxEnDlyTg0_u1_p2 @0 {
       bits 11;
       access rw;
       reset 11'h100;
    }
  }
  register RxEnDlyTg1_u1_p2 @'h200181 {
    field RxEnDlyTg1_u1_p2 @0 {
       bits 11;
       access rw;
       reset 11'h100;
    }
  }
  register RxEnDlyTg2_u1_p2 @'h200182 {
    field RxEnDlyTg2_u1_p2 @0 {
       bits 11;
       access rw;
       reset 11'h100;
    }
  }
  register RxEnDlyTg3_u1_p2 @'h200183 {
    field RxEnDlyTg3_u1_p2 @0 {
       bits 11;
       access rw;
       reset 11'h100;
    }
  }
  register RxClkDlyTg0_u1_p2 @'h20018c {
    field RxClkDlyTg0_u1_p2 @0 {
       bits 6;
       access rw;
       reset 6'h10;
    }
  }
  register RxClkDlyTg1_u1_p2 @'h20018d {
    field RxClkDlyTg1_u1_p2 @0 {
       bits 6;
       access rw;
       reset 6'h10;
    }
  }
  register RxClkDlyTg2_u1_p2 @'h20018e {
    field RxClkDlyTg2_u1_p2 @0 {
       bits 6;
       access rw;
       reset 6'h10;
    }
  }
  register RxClkDlyTg3_u1_p2 @'h20018f {
    field RxClkDlyTg3_u1_p2 @0 {
       bits 6;
       access rw;
       reset 6'h10;
    }
  }
  register RxClkcDlyTg0_u1_p2 @'h200190 {
    field RxClkcDlyTg0_u1_p2 @0 {
       bits 6;
       access rw;
       reset 6'h10;
    }
  }
  register RxClkcDlyTg1_u1_p2 @'h200191 {
    field RxClkcDlyTg1_u1_p2 @0 {
       bits 6;
       access rw;
       reset 6'h10;
    }
  }
  register RxClkcDlyTg2_u1_p2 @'h200192 {
    field RxClkcDlyTg2_u1_p2 @0 {
       bits 6;
       access rw;
       reset 6'h10;
    }
  }
  register RxClkcDlyTg3_u1_p2 @'h200193 {
    field RxClkcDlyTg3_u1_p2 @0 {
       bits 6;
       access rw;
       reset 6'h10;
    }
  }
  register TxDqDlyTg0_r1_p2 @'h2001c0 {
    field TxDqDlyTg0_r1_p2 @0 {
       bits 9;
       access rw;
       reset 9'h10;
    }
  }
  register TxDqDlyTg1_r1_p2 @'h2001c1 {
    field TxDqDlyTg1_r1_p2 @0 {
       bits 9;
       access rw;
       reset 9'h10;
    }
  }
  register TxDqDlyTg2_r1_p2 @'h2001c2 {
    field TxDqDlyTg2_r1_p2 @0 {
       bits 9;
       access rw;
       reset 9'h10;
    }
  }
  register TxDqDlyTg3_r1_p2 @'h2001c3 {
    field TxDqDlyTg3_r1_p2 @0 {
       bits 9;
       access rw;
       reset 9'h10;
    }
  }
  register TxDqsDlyTg0_u1_p2 @'h2001d0 {
    field TxDqsDlyTg0_u1_p2 @0 {
       bits 10;
       access rw;
       reset 10'h100;
    }
  }
  register TxDqsDlyTg1_u1_p2 @'h2001d1 {
    field TxDqsDlyTg1_u1_p2 @0 {
       bits 10;
       access rw;
       reset 10'h100;
    }
  }
  register TxDqsDlyTg2_u1_p2 @'h2001d2 {
    field TxDqsDlyTg2_u1_p2 @0 {
       bits 10;
       access rw;
       reset 10'h100;
    }
  }
  register TxDqsDlyTg3_u1_p2 @'h2001d3 {
    field TxDqsDlyTg3_u1_p2 @0 {
       bits 10;
       access rw;
       reset 10'h100;
    }
  }
  register TxDqDlyTg0_r2_p2 @'h2002c0 {
    field TxDqDlyTg0_r2_p2 @0 {
       bits 9;
       access rw;
       reset 9'h10;
    }
  }
  register TxDqDlyTg1_r2_p2 @'h2002c1 {
    field TxDqDlyTg1_r2_p2 @0 {
       bits 9;
       access rw;
       reset 9'h10;
    }
  }
  register TxDqDlyTg2_r2_p2 @'h2002c2 {
    field TxDqDlyTg2_r2_p2 @0 {
       bits 9;
       access rw;
       reset 9'h10;
    }
  }
  register TxDqDlyTg3_r2_p2 @'h2002c3 {
    field TxDqDlyTg3_r2_p2 @0 {
       bits 9;
       access rw;
       reset 9'h10;
    }
  }
  register TxDqDlyTg0_r3_p2 @'h2003c0 {
    field TxDqDlyTg0_r3_p2 @0 {
       bits 9;
       access rw;
       reset 9'h10;
    }
  }
  register TxDqDlyTg1_r3_p2 @'h2003c1 {
    field TxDqDlyTg1_r3_p2 @0 {
       bits 9;
       access rw;
       reset 9'h10;
    }
  }
  register TxDqDlyTg2_r3_p2 @'h2003c2 {
    field TxDqDlyTg2_r3_p2 @0 {
       bits 9;
       access rw;
       reset 9'h10;
    }
  }
  register TxDqDlyTg3_r3_p2 @'h2003c3 {
    field TxDqDlyTg3_r3_p2 @0 {
       bits 9;
       access rw;
       reset 9'h10;
    }
  }
  register TxDqDlyTg0_r4_p2 @'h2004c0 {
    field TxDqDlyTg0_r4_p2 @0 {
       bits 9;
       access rw;
       reset 9'h10;
    }
  }
  register TxDqDlyTg1_r4_p2 @'h2004c1 {
    field TxDqDlyTg1_r4_p2 @0 {
       bits 9;
       access rw;
       reset 9'h10;
    }
  }
  register TxDqDlyTg2_r4_p2 @'h2004c2 {
    field TxDqDlyTg2_r4_p2 @0 {
       bits 9;
       access rw;
       reset 9'h10;
    }
  }
  register TxDqDlyTg3_r4_p2 @'h2004c3 {
    field TxDqDlyTg3_r4_p2 @0 {
       bits 9;
       access rw;
       reset 9'h10;
    }
  }
  register TxDqDlyTg0_r5_p2 @'h2005c0 {
    field TxDqDlyTg0_r5_p2 @0 {
       bits 9;
       access rw;
       reset 9'h10;
    }
  }
  register TxDqDlyTg1_r5_p2 @'h2005c1 {
    field TxDqDlyTg1_r5_p2 @0 {
       bits 9;
       access rw;
       reset 9'h10;
    }
  }
  register TxDqDlyTg2_r5_p2 @'h2005c2 {
    field TxDqDlyTg2_r5_p2 @0 {
       bits 9;
       access rw;
       reset 9'h10;
    }
  }
  register TxDqDlyTg3_r5_p2 @'h2005c3 {
    field TxDqDlyTg3_r5_p2 @0 {
       bits 9;
       access rw;
       reset 9'h10;
    }
  }
  register TxDqDlyTg0_r6_p2 @'h2006c0 {
    field TxDqDlyTg0_r6_p2 @0 {
       bits 9;
       access rw;
       reset 9'h10;
    }
  }
  register TxDqDlyTg1_r6_p2 @'h2006c1 {
    field TxDqDlyTg1_r6_p2 @0 {
       bits 9;
       access rw;
       reset 9'h10;
    }
  }
  register TxDqDlyTg2_r6_p2 @'h2006c2 {
    field TxDqDlyTg2_r6_p2 @0 {
       bits 9;
       access rw;
       reset 9'h10;
    }
  }
  register TxDqDlyTg3_r6_p2 @'h2006c3 {
    field TxDqDlyTg3_r6_p2 @0 {
       bits 9;
       access rw;
       reset 9'h10;
    }
  }
  register TxDqDlyTg0_r7_p2 @'h2007c0 {
    field TxDqDlyTg0_r7_p2 @0 {
       bits 9;
       access rw;
       reset 9'h10;
    }
  }
  register TxDqDlyTg1_r7_p2 @'h2007c1 {
    field TxDqDlyTg1_r7_p2 @0 {
       bits 9;
       access rw;
       reset 9'h10;
    }
  }
  register TxDqDlyTg2_r7_p2 @'h2007c2 {
    field TxDqDlyTg2_r7_p2 @0 {
       bits 9;
       access rw;
       reset 9'h10;
    }
  }
  register TxDqDlyTg3_r7_p2 @'h2007c3 {
    field TxDqDlyTg3_r7_p2 @0 {
       bits 9;
       access rw;
       reset 9'h10;
    }
  }
  register TxDqDlyTg0_r8_p2 @'h2008c0 {
    field TxDqDlyTg0_r8_p2 @0 {
       bits 9;
       access rw;
       reset 9'h10;
    }
  }
  register TxDqDlyTg1_r8_p2 @'h2008c1 {
    field TxDqDlyTg1_r8_p2 @0 {
       bits 9;
       access rw;
       reset 9'h10;
    }
  }
  register TxDqDlyTg2_r8_p2 @'h2008c2 {
    field TxDqDlyTg2_r8_p2 @0 {
       bits 9;
       access rw;
       reset 9'h10;
    }
  }
  register TxDqDlyTg3_r8_p2 @'h2008c3 {
    field TxDqDlyTg3_r8_p2 @0 {
       bits 9;
       access rw;
       reset 9'h10;
    }
  }
  register UseDqsEnReplica_p3 @'h300003 {
    field UseDqsEnReplica_p3 @0 {
       bits 1;
       access rw;
       reset 1'h0;
    }
  }
  register DFIMRL_p3 @'h300020 {
    field DFIMRL_p3 @0 {
       bits 5;
       access rw;
       reset 5'h6;
    }
  }
  register TxImpedanceCtrl0_b0_p3 @'h300041 {
    field DrvStrenDqP @0 {
       bits 6;
       access rw;
       reset 6'h3f;
    }
    field DrvStrenDqN @6 {
       bits 6;
       access rw;
       reset 6'h3f;
    }
  }
  register DqDqsRcvCntrl_b0_p3 @'h300043 {
    field SelAnalogVref @0 {
       bits 1;
       access rw;
       reset 1'h0;
    }
    field ExtVrefRange @1 {
       bits 1;
       access rw;
       reset 1'h0;
    }
    field DfeCtrl @2 {
       bits 2;
       access rw;
       reset 2'h0;
    }
    field MajorModeDbyte @4 {
       bits 3;
       access rw;
       reset 3'h3;
    }
    field GainCurrAdj @7 {
       bits 5;
       access rw;
       reset 5'hb;
    }
    field Reserved @12 {
       bits 4;
    }
  }
  register TxEqualizationMode_p3 @'h300048 {
    field TxEqMode @0 {
       bits 2;
       access rw;
       reset 2'h0;
    }
  }
  register TxImpedanceCtrl1_b0_p3 @'h300049 {
    field DrvStrenFSDqP @0 {
       bits 6;
       access rw;
       reset 6'h3f;
    }
    field DrvStrenFSDqN @6 {
       bits 6;
       access rw;
       reset 6'h3f;
    }
  }
  register TxImpedanceCtrl2_b0_p3 @'h30004b {
    field DrvStrenEQHiDqP @0 {
       bits 6;
       access rw;
       reset 6'h0;
    }
    field DrvStrenEQLoDqN @6 {
       bits 6;
       access rw;
       reset 6'h0;
    }
  }
  register DqDqsRcvCntrl2_p3 @'h30004c {
    field EnRxAgressivePDR @0 {
       bits 1;
       access rw;
       reset 1'h0;
    }
  }
  register TxOdtDrvStren_b0_p3 @'h30004d {
    field ODTStrenP @0 {
       bits 6;
       access rw;
       reset 6'h0;
    }
    field ODTStrenN @6 {
       bits 6;
       access rw;
       reset 6'h0;
    }
  }
  register TxSlewRate_b0_p3 @'h30005f {
    field TxPreP @0 {
       bits 4;
       access rw;
       reset 4'hf;
    }
    field TxPreN @4 {
       bits 4;
       access rw;
       reset 4'hf;
    }
    field TxPreDrvMode @8 {
       bits 3;
       access rw;
       reset 3'h7;
    }
  }
  register RxEnDlyTg0_u0_p3 @'h300080 {
    field RxEnDlyTg0_u0_p3 @0 {
       bits 11;
       access rw;
       reset 11'h100;
    }
  }
  register RxEnDlyTg1_u0_p3 @'h300081 {
    field RxEnDlyTg1_u0_p3 @0 {
       bits 11;
       access rw;
       reset 11'h100;
    }
  }
  register RxEnDlyTg2_u0_p3 @'h300082 {
    field RxEnDlyTg2_u0_p3 @0 {
       bits 11;
       access rw;
       reset 11'h100;
    }
  }
  register RxEnDlyTg3_u0_p3 @'h300083 {
    field RxEnDlyTg3_u0_p3 @0 {
       bits 11;
       access rw;
       reset 11'h100;
    }
  }
  register RxClkDlyTg0_u0_p3 @'h30008c {
    field RxClkDlyTg0_u0_p3 @0 {
       bits 6;
       access rw;
       reset 6'h10;
    }
  }
  register RxClkDlyTg1_u0_p3 @'h30008d {
    field RxClkDlyTg1_u0_p3 @0 {
       bits 6;
       access rw;
       reset 6'h10;
    }
  }
  register RxClkDlyTg2_u0_p3 @'h30008e {
    field RxClkDlyTg2_u0_p3 @0 {
       bits 6;
       access rw;
       reset 6'h10;
    }
  }
  register RxClkDlyTg3_u0_p3 @'h30008f {
    field RxClkDlyTg3_u0_p3 @0 {
       bits 6;
       access rw;
       reset 6'h10;
    }
  }
  register RxClkcDlyTg0_u0_p3 @'h300090 {
    field RxClkcDlyTg0_u0_p3 @0 {
       bits 6;
       access rw;
       reset 6'h10;
    }
  }
  register RxClkcDlyTg1_u0_p3 @'h300091 {
    field RxClkcDlyTg1_u0_p3 @0 {
       bits 6;
       access rw;
       reset 6'h10;
    }
  }
  register RxClkcDlyTg2_u0_p3 @'h300092 {
    field RxClkcDlyTg2_u0_p3 @0 {
       bits 6;
       access rw;
       reset 6'h10;
    }
  }
  register RxClkcDlyTg3_u0_p3 @'h300093 {
    field RxClkcDlyTg3_u0_p3 @0 {
       bits 6;
       access rw;
       reset 6'h10;
    }
  }
  register PptDqsCntInvTrnTg0_p3 @'h3000ae {
    field PptDqsCntInvTrnTg0_p3 @0 {
       bits 16;
       access rw;
       reset 16'h0;
    }
  }
  register PptDqsCntInvTrnTg1_p3 @'h3000af {
    field PptDqsCntInvTrnTg1_p3 @0 {
       bits 16;
       access rw;
       reset 16'h0;
    }
  }
  register TxDqDlyTg0_r0_p3 @'h3000c0 {
    field TxDqDlyTg0_r0_p3 @0 {
       bits 9;
       access rw;
       reset 9'h10;
    }
  }
  register TxDqDlyTg1_r0_p3 @'h3000c1 {
    field TxDqDlyTg1_r0_p3 @0 {
       bits 9;
       access rw;
       reset 9'h10;
    }
  }
  register TxDqDlyTg2_r0_p3 @'h3000c2 {
    field TxDqDlyTg2_r0_p3 @0 {
       bits 9;
       access rw;
       reset 9'h10;
    }
  }
  register TxDqDlyTg3_r0_p3 @'h3000c3 {
    field TxDqDlyTg3_r0_p3 @0 {
       bits 9;
       access rw;
       reset 9'h10;
    }
  }
  register TxDqsDlyTg0_u0_p3 @'h3000d0 {
    field TxDqsDlyTg0_u0_p3 @0 {
       bits 10;
       access rw;
       reset 10'h100;
    }
  }
  register TxDqsDlyTg1_u0_p3 @'h3000d1 {
    field TxDqsDlyTg1_u0_p3 @0 {
       bits 10;
       access rw;
       reset 10'h100;
    }
  }
  register TxDqsDlyTg2_u0_p3 @'h3000d2 {
    field TxDqsDlyTg2_u0_p3 @0 {
       bits 10;
       access rw;
       reset 10'h100;
    }
  }
  register TxDqsDlyTg3_u0_p3 @'h3000d3 {
    field TxDqsDlyTg3_u0_p3 @0 {
       bits 10;
       access rw;
       reset 10'h100;
    }
  }
  register TxImpedanceCtrl0_b1_p3 @'h300141 {
    field DrvStrenDqP @0 {
       bits 6;
       access rw;
       reset 6'h3f;
    }
    field DrvStrenDqN @6 {
       bits 6;
       access rw;
       reset 6'h3f;
    }
  }
  register DqDqsRcvCntrl_b1_p3 @'h300143 {
    field SelAnalogVref @0 {
       bits 1;
       access rw;
       reset 1'h0;
    }
    field ExtVrefRange @1 {
       bits 1;
       access rw;
       reset 1'h0;
    }
    field DfeCtrl @2 {
       bits 2;
       access rw;
       reset 2'h0;
    }
    field MajorModeDbyte @4 {
       bits 3;
       access rw;
       reset 3'h3;
    }
    field GainCurrAdj @7 {
       bits 5;
       access rw;
       reset 5'hb;
    }
    field Reserved @12 {
       bits 4;
    }
  }
  register TxImpedanceCtrl1_b1_p3 @'h300149 {
    field DrvStrenFSDqP @0 {
       bits 6;
       access rw;
       reset 6'h3f;
    }
    field DrvStrenFSDqN @6 {
       bits 6;
       access rw;
       reset 6'h3f;
    }
  }
  register TxImpedanceCtrl2_b1_p3 @'h30014b {
    field DrvStrenEQHiDqP @0 {
       bits 6;
       access rw;
       reset 6'h0;
    }
    field DrvStrenEQLoDqN @6 {
       bits 6;
       access rw;
       reset 6'h0;
    }
  }
  register TxOdtDrvStren_b1_p3 @'h30014d {
    field ODTStrenP @0 {
       bits 6;
       access rw;
       reset 6'h0;
    }
    field ODTStrenN @6 {
       bits 6;
       access rw;
       reset 6'h0;
    }
  }
  register TxSlewRate_b1_p3 @'h30015f {
    field TxPreP @0 {
       bits 4;
       access rw;
       reset 4'hf;
    }
    field TxPreN @4 {
       bits 4;
       access rw;
       reset 4'hf;
    }
    field TxPreDrvMode @8 {
       bits 3;
       access rw;
       reset 3'h7;
    }
  }
  register RxEnDlyTg0_u1_p3 @'h300180 {
    field RxEnDlyTg0_u1_p3 @0 {
       bits 11;
       access rw;
       reset 11'h100;
    }
  }
  register RxEnDlyTg1_u1_p3 @'h300181 {
    field RxEnDlyTg1_u1_p3 @0 {
       bits 11;
       access rw;
       reset 11'h100;
    }
  }
  register RxEnDlyTg2_u1_p3 @'h300182 {
    field RxEnDlyTg2_u1_p3 @0 {
       bits 11;
       access rw;
       reset 11'h100;
    }
  }
  register RxEnDlyTg3_u1_p3 @'h300183 {
    field RxEnDlyTg3_u1_p3 @0 {
       bits 11;
       access rw;
       reset 11'h100;
    }
  }
  register RxClkDlyTg0_u1_p3 @'h30018c {
    field RxClkDlyTg0_u1_p3 @0 {
       bits 6;
       access rw;
       reset 6'h10;
    }
  }
  register RxClkDlyTg1_u1_p3 @'h30018d {
    field RxClkDlyTg1_u1_p3 @0 {
       bits 6;
       access rw;
       reset 6'h10;
    }
  }
  register RxClkDlyTg2_u1_p3 @'h30018e {
    field RxClkDlyTg2_u1_p3 @0 {
       bits 6;
       access rw;
       reset 6'h10;
    }
  }
  register RxClkDlyTg3_u1_p3 @'h30018f {
    field RxClkDlyTg3_u1_p3 @0 {
       bits 6;
       access rw;
       reset 6'h10;
    }
  }
  register RxClkcDlyTg0_u1_p3 @'h300190 {
    field RxClkcDlyTg0_u1_p3 @0 {
       bits 6;
       access rw;
       reset 6'h10;
    }
  }
  register RxClkcDlyTg1_u1_p3 @'h300191 {
    field RxClkcDlyTg1_u1_p3 @0 {
       bits 6;
       access rw;
       reset 6'h10;
    }
  }
  register RxClkcDlyTg2_u1_p3 @'h300192 {
    field RxClkcDlyTg2_u1_p3 @0 {
       bits 6;
       access rw;
       reset 6'h10;
    }
  }
  register RxClkcDlyTg3_u1_p3 @'h300193 {
    field RxClkcDlyTg3_u1_p3 @0 {
       bits 6;
       access rw;
       reset 6'h10;
    }
  }
  register TxDqDlyTg0_r1_p3 @'h3001c0 {
    field TxDqDlyTg0_r1_p3 @0 {
       bits 9;
       access rw;
       reset 9'h10;
    }
  }
  register TxDqDlyTg1_r1_p3 @'h3001c1 {
    field TxDqDlyTg1_r1_p3 @0 {
       bits 9;
       access rw;
       reset 9'h10;
    }
  }
  register TxDqDlyTg2_r1_p3 @'h3001c2 {
    field TxDqDlyTg2_r1_p3 @0 {
       bits 9;
       access rw;
       reset 9'h10;
    }
  }
  register TxDqDlyTg3_r1_p3 @'h3001c3 {
    field TxDqDlyTg3_r1_p3 @0 {
       bits 9;
       access rw;
       reset 9'h10;
    }
  }
  register TxDqsDlyTg0_u1_p3 @'h3001d0 {
    field TxDqsDlyTg0_u1_p3 @0 {
       bits 10;
       access rw;
       reset 10'h100;
    }
  }
  register TxDqsDlyTg1_u1_p3 @'h3001d1 {
    field TxDqsDlyTg1_u1_p3 @0 {
       bits 10;
       access rw;
       reset 10'h100;
    }
  }
  register TxDqsDlyTg2_u1_p3 @'h3001d2 {
    field TxDqsDlyTg2_u1_p3 @0 {
       bits 10;
       access rw;
       reset 10'h100;
    }
  }
  register TxDqsDlyTg3_u1_p3 @'h3001d3 {
    field TxDqsDlyTg3_u1_p3 @0 {
       bits 10;
       access rw;
       reset 10'h100;
    }
  }
  register TxDqDlyTg0_r2_p3 @'h3002c0 {
    field TxDqDlyTg0_r2_p3 @0 {
       bits 9;
       access rw;
       reset 9'h10;
    }
  }
  register TxDqDlyTg1_r2_p3 @'h3002c1 {
    field TxDqDlyTg1_r2_p3 @0 {
       bits 9;
       access rw;
       reset 9'h10;
    }
  }
  register TxDqDlyTg2_r2_p3 @'h3002c2 {
    field TxDqDlyTg2_r2_p3 @0 {
       bits 9;
       access rw;
       reset 9'h10;
    }
  }
  register TxDqDlyTg3_r2_p3 @'h3002c3 {
    field TxDqDlyTg3_r2_p3 @0 {
       bits 9;
       access rw;
       reset 9'h10;
    }
  }
  register TxDqDlyTg0_r3_p3 @'h3003c0 {
    field TxDqDlyTg0_r3_p3 @0 {
       bits 9;
       access rw;
       reset 9'h10;
    }
  }
  register TxDqDlyTg1_r3_p3 @'h3003c1 {
    field TxDqDlyTg1_r3_p3 @0 {
       bits 9;
       access rw;
       reset 9'h10;
    }
  }
  register TxDqDlyTg2_r3_p3 @'h3003c2 {
    field TxDqDlyTg2_r3_p3 @0 {
       bits 9;
       access rw;
       reset 9'h10;
    }
  }
  register TxDqDlyTg3_r3_p3 @'h3003c3 {
    field TxDqDlyTg3_r3_p3 @0 {
       bits 9;
       access rw;
       reset 9'h10;
    }
  }
  register TxDqDlyTg0_r4_p3 @'h3004c0 {
    field TxDqDlyTg0_r4_p3 @0 {
       bits 9;
       access rw;
       reset 9'h10;
    }
  }
  register TxDqDlyTg1_r4_p3 @'h3004c1 {
    field TxDqDlyTg1_r4_p3 @0 {
       bits 9;
       access rw;
       reset 9'h10;
    }
  }
  register TxDqDlyTg2_r4_p3 @'h3004c2 {
    field TxDqDlyTg2_r4_p3 @0 {
       bits 9;
       access rw;
       reset 9'h10;
    }
  }
  register TxDqDlyTg3_r4_p3 @'h3004c3 {
    field TxDqDlyTg3_r4_p3 @0 {
       bits 9;
       access rw;
       reset 9'h10;
    }
  }
  register TxDqDlyTg0_r5_p3 @'h3005c0 {
    field TxDqDlyTg0_r5_p3 @0 {
       bits 9;
       access rw;
       reset 9'h10;
    }
  }
  register TxDqDlyTg1_r5_p3 @'h3005c1 {
    field TxDqDlyTg1_r5_p3 @0 {
       bits 9;
       access rw;
       reset 9'h10;
    }
  }
  register TxDqDlyTg2_r5_p3 @'h3005c2 {
    field TxDqDlyTg2_r5_p3 @0 {
       bits 9;
       access rw;
       reset 9'h10;
    }
  }
  register TxDqDlyTg3_r5_p3 @'h3005c3 {
    field TxDqDlyTg3_r5_p3 @0 {
       bits 9;
       access rw;
       reset 9'h10;
    }
  }
  register TxDqDlyTg0_r6_p3 @'h3006c0 {
    field TxDqDlyTg0_r6_p3 @0 {
       bits 9;
       access rw;
       reset 9'h10;
    }
  }
  register TxDqDlyTg1_r6_p3 @'h3006c1 {
    field TxDqDlyTg1_r6_p3 @0 {
       bits 9;
       access rw;
       reset 9'h10;
    }
  }
  register TxDqDlyTg2_r6_p3 @'h3006c2 {
    field TxDqDlyTg2_r6_p3 @0 {
       bits 9;
       access rw;
       reset 9'h10;
    }
  }
  register TxDqDlyTg3_r6_p3 @'h3006c3 {
    field TxDqDlyTg3_r6_p3 @0 {
       bits 9;
       access rw;
       reset 9'h10;
    }
  }
  register TxDqDlyTg0_r7_p3 @'h3007c0 {
    field TxDqDlyTg0_r7_p3 @0 {
       bits 9;
       access rw;
       reset 9'h10;
    }
  }
  register TxDqDlyTg1_r7_p3 @'h3007c1 {
    field TxDqDlyTg1_r7_p3 @0 {
       bits 9;
       access rw;
       reset 9'h10;
    }
  }
  register TxDqDlyTg2_r7_p3 @'h3007c2 {
    field TxDqDlyTg2_r7_p3 @0 {
       bits 9;
       access rw;
       reset 9'h10;
    }
  }
  register TxDqDlyTg3_r7_p3 @'h3007c3 {
    field TxDqDlyTg3_r7_p3 @0 {
       bits 9;
       access rw;
       reset 9'h10;
    }
  }
  register TxDqDlyTg0_r8_p3 @'h3008c0 {
    field TxDqDlyTg0_r8_p3 @0 {
       bits 9;
       access rw;
       reset 9'h10;
    }
  }
  register TxDqDlyTg1_r8_p3 @'h3008c1 {
    field TxDqDlyTg1_r8_p3 @0 {
       bits 9;
       access rw;
       reset 9'h10;
    }
  }
  register TxDqDlyTg2_r8_p3 @'h3008c2 {
    field TxDqDlyTg2_r8_p3 @0 {
       bits 9;
       access rw;
       reset 9'h10;
    }
  }
  register TxDqDlyTg3_r8_p3 @'h3008c3 {
    field TxDqDlyTg3_r8_p3 @0 {
       bits 9;
       access rw;
       reset 9'h10;
    }
  }
}
block dwc_ddrphy_top_DWC_DDRPHYA_DBYTE1 {
  endian little;
  bytes 2;
  register DbyteMiscMode @'h0 {
    field Reserved @0 {
       bits 2;
    }
    field DByteDisable @2 {
       bits 1;
       access rw;
       reset 1'h0;
    }
  }
  register TsmByte0 @'h1 {
    field RFU_TsmByte0 @0 {
       bits 16;
       access rw;
       reset 16'h0;
    }
  }
  register TrainingParam @'h2 {
    field RFU_TrainingParam @0 {
       bits 16;
       access rw;
       reset 16'h0;
    }
  }
  register UseDqsEnReplica_p0 @'h3 {
    field UseDqsEnReplica_p0 @0 {
       bits 1;
       access rw;
       reset 1'h0;
    }
  }
  register RxTrainPatternEnable @'h10 {
    field RxTrainPatternEnable @0 {
       bits 1;
       access rw;
       reset 1'h0;
    }
  }
  register TsmByte1 @'h11 {
    field RFU_TsmByte1 @0 {
       bits 16;
       access rw;
       reset 16'h0;
    }
  }
  register TsmByte2 @'h12 {
    field RFU_TsmByte2 @0 {
       bits 16;
       access rw;
       reset 16'h0;
    }
  }
  register TsmByte3 @'h13 {
    field RFU_TsmByte3 @0 {
       bits 9;
       access rw;
       reset 9'h0;
    }
  }
  register TsmByte4 @'h14 {
    field RFU_TsmByte4 @0 {
       bits 4;
       access rw;
       reset 4'h0;
    }
  }
  register TestModeConfig @'h17 {
    field RFU_TestModeConfig @0 {
       bits 10;
       access rw;
       reset 10'h0;
    }
  }
  register TsmByte5 @'h18 {
    field RFU_TsmByte5 @0 {
       bits 16;
       access rw;
       reset 16'h0;
    }
  }
  register MtestMuxSel @'h1a {
    field MtestMuxSel @0 {
       bits 6;
       access rw;
       reset 6'h0;
    }
  }
  register DtsmTrainModeCtrl @'h1f {
    field RFU_DtsmTrainModeCtrl @0 {
       bits 4;
       access rw;
       reset 4'h0;
    }
  }
  register DFIMRL_p0 @'h20 {
    field DFIMRL_p0 @0 {
       bits 5;
       access rw;
       reset 5'h6;
    }
  }
  register AsyncDbyteMode @'h24 {
    field AsyncDbyteMode @0 {
       bits 9;
       access rw;
       reset 9'h0;
    }
  }
  register AsyncDbyteTxEn @'h26 {
    field AsyncDbyteTxEn @0 {
       bits 12;
       access rw;
       reset 12'h0;
    }
  }
  register AsyncDbyteTxData @'h28 {
    field AsyncDbyteTxData @0 {
       bits 12;
       access rw;
       reset 12'h0;
    }
  }
  register AsyncDbyteRxData @'h2a {
    field AsyncDbyteRxData @0 {
       bits 12;
       access ro;
       reset 12'h0;
    }
  }
  register VrefDAC1_r0 @'h30 {
    field VrefDAC1_r0 @0 {
       bits 7;
       access rw;
       reset 7'h0;
    }
  }
  register TrainingCntr_r0 @'h32 {
    field RFU_TrainingCntr_r0 @0 {
       bits 16;
       access rw;
       reset 16'h0;
    }
  }
  register VrefDAC0_r0 @'h40 {
    field VrefDAC0_r0 @0 {
       bits 7;
       access rw;
       reset 7'h0;
    }
  }
  register TxImpedanceCtrl0_b0_p0 @'h41 {
    field DrvStrenDqP @0 {
       bits 6;
       access rw;
       reset 6'h3f;
    }
    field DrvStrenDqN @6 {
       bits 6;
       access rw;
       reset 6'h3f;
    }
  }
  register DqDqsRcvCntrl_b0_p0 @'h43 {
    field SelAnalogVref @0 {
       bits 1;
       access rw;
       reset 1'h0;
    }
    field ExtVrefRange @1 {
       bits 1;
       access rw;
       reset 1'h0;
    }
    field DfeCtrl @2 {
       bits 2;
       access rw;
       reset 2'h0;
    }
    field MajorModeDbyte @4 {
       bits 3;
       access rw;
       reset 3'h3;
    }
    field GainCurrAdj @7 {
       bits 5;
       access rw;
       reset 5'hb;
    }
    field Reserved @12 {
       bits 4;
    }
  }
  register TxEqualizationMode_p0 @'h48 {
    field TxEqMode @0 {
       bits 2;
       access rw;
       reset 2'h0;
    }
  }
  register TxImpedanceCtrl1_b0_p0 @'h49 {
    field DrvStrenFSDqP @0 {
       bits 6;
       access rw;
       reset 6'h3f;
    }
    field DrvStrenFSDqN @6 {
       bits 6;
       access rw;
       reset 6'h3f;
    }
  }
  register DqDqsRcvCntrl1 @'h4a {
    field PowerDownRcvr @0 {
       bits 9;
       access rw;
       reset 9'h0;
    }
    field PowerDownRcvrDqs @9 {
       bits 1;
       access rw;
       reset 1'h0;
    }
    field RxPadStandbyEn @10 {
       bits 1;
       access rw;
       reset 1'h1;
    }
    field EnLPReqPDR @11 {
       bits 1;
       access rw;
       reset 1'h0;
    }
  }
  register TxImpedanceCtrl2_b0_p0 @'h4b {
    field DrvStrenEQHiDqP @0 {
       bits 6;
       access rw;
       reset 6'h0;
    }
    field DrvStrenEQLoDqN @6 {
       bits 6;
       access rw;
       reset 6'h0;
    }
  }
  register DqDqsRcvCntrl2_p0 @'h4c {
    field EnRxAgressivePDR @0 {
       bits 1;
       access rw;
       reset 1'h0;
    }
  }
  register TxOdtDrvStren_b0_p0 @'h4d {
    field ODTStrenP @0 {
       bits 6;
       access rw;
       reset 6'h0;
    }
    field ODTStrenN @6 {
       bits 6;
       access rw;
       reset 6'h0;
    }
  }
  register RxFifoCheckStatus @'h56 {
    field RxFifoLocErr @0 {
       bits 1;
       access ro;
       reset 1'h0;
    }
    field RxFifoLocUErr @1 {
       bits 1;
       access ro;
       reset 1'h0;
    }
  }
  register RxFifoCheckErrValues @'h57 {
    field RxFifoRdLocErrValue @0 {
       bits 4;
       access ro;
       reset 4'h0;
    }
    field RxFifoWrLocErrValue @4 {
       bits 4;
       access ro;
       reset 4'h0;
    }
    field RxFifoRdLocUErrValue @8 {
       bits 4;
       access ro;
       reset 4'h0;
    }
    field RxFifoWrLocUErrValue @12 {
       bits 4;
       access ro;
       reset 4'h0;
    }
  }
  register RxFifoInfo @'h58 {
    field RxFifoRdLoc @0 {
       bits 4;
       access ro;
       reset 4'h0;
    }
    field RxFifoWrLoc @4 {
       bits 4;
       access ro;
       reset 4'h0;
    }
    field RxFifoRdLocU @8 {
       bits 4;
       access ro;
       reset 4'h0;
    }
    field RxFifoWrLocU @12 {
       bits 4;
       access ro;
       reset 4'h0;
    }
  }
  register RxFifoVisibility @'h59 {
    field RxFifoRdPtr @0 {
       bits 3;
       access rw;
       reset 3'h0;
    }
    field RxFifoRdPtrOvr @3 {
       bits 1;
       access rw;
       reset 1'h0;
    }
    field RxFifoRdEn @4 {
       bits 1;
       access rw;
       reset 1'h0;
    }
  }
  register RxFifoContentsDQ3210 @'h5a {
    field RxFifoContentsDQ3210 @0 {
       bits 16;
       access ro;
       reset 16'h0;
    }
  }
  register RxFifoContentsDQ7654 @'h5b {
    field RxFifoContentsDQ7654 @0 {
       bits 16;
       access ro;
       reset 16'h0;
    }
  }
  register RxFifoContentsDBI @'h5c {
    field RxFifoContentsDBI @0 {
       bits 4;
       access ro;
       reset 4'h0;
    }
  }
  register TxSlewRate_b0_p0 @'h5f {
    field TxPreP @0 {
       bits 4;
       access rw;
       reset 4'hf;
    }
    field TxPreN @4 {
       bits 4;
       access rw;
       reset 4'hf;
    }
    field TxPreDrvMode @8 {
       bits 3;
       access rw;
       reset 3'h7;
    }
  }
  register TrainingIncDecDtsmEn_r0 @'h62 {
    field TrainingIncDecDtsmEn_r0 @0 {
       bits 9;
       access rw;
       reset 9'h0;
    }
  }
  register RxPBDlyTg0_r0 @'h68 {
    field RxPBDlyTg0_r0 @0 {
       bits 7;
       access rw;
       reset 7'h0;
    }
  }
  register RxPBDlyTg1_r0 @'h69 {
    field RxPBDlyTg1_r0 @0 {
       bits 7;
       access rw;
       reset 7'h0;
    }
  }
  register RxPBDlyTg2_r0 @'h6a {
    field RxPBDlyTg2_r0 @0 {
       bits 7;
       access rw;
       reset 7'h0;
    }
  }
  register RxPBDlyTg3_r0 @'h6b {
    field RxPBDlyTg3_r0 @0 {
       bits 7;
       access rw;
       reset 7'h0;
    }
  }
  register RxEnDlyTg0_u0_p0 @'h80 {
    field RxEnDlyTg0_u0_p0 @0 {
       bits 11;
       access rw;
       reset 11'h100;
    }
  }
  register RxEnDlyTg1_u0_p0 @'h81 {
    field RxEnDlyTg1_u0_p0 @0 {
       bits 11;
       access rw;
       reset 11'h100;
    }
  }
  register RxEnDlyTg2_u0_p0 @'h82 {
    field RxEnDlyTg2_u0_p0 @0 {
       bits 11;
       access rw;
       reset 11'h100;
    }
  }
  register RxEnDlyTg3_u0_p0 @'h83 {
    field RxEnDlyTg3_u0_p0 @0 {
       bits 11;
       access rw;
       reset 11'h100;
    }
  }
  register RxClkDlyTg0_u0_p0 @'h8c {
    field RxClkDlyTg0_u0_p0 @0 {
       bits 6;
       access rw;
       reset 6'h10;
    }
  }
  register RxClkDlyTg1_u0_p0 @'h8d {
    field RxClkDlyTg1_u0_p0 @0 {
       bits 6;
       access rw;
       reset 6'h10;
    }
  }
  register RxClkDlyTg2_u0_p0 @'h8e {
    field RxClkDlyTg2_u0_p0 @0 {
       bits 6;
       access rw;
       reset 6'h10;
    }
  }
  register RxClkDlyTg3_u0_p0 @'h8f {
    field RxClkDlyTg3_u0_p0 @0 {
       bits 6;
       access rw;
       reset 6'h10;
    }
  }
  register RxClkcDlyTg0_u0_p0 @'h90 {
    field RxClkcDlyTg0_u0_p0 @0 {
       bits 6;
       access rw;
       reset 6'h10;
    }
  }
  register RxClkcDlyTg1_u0_p0 @'h91 {
    field RxClkcDlyTg1_u0_p0 @0 {
       bits 6;
       access rw;
       reset 6'h10;
    }
  }
  register RxClkcDlyTg2_u0_p0 @'h92 {
    field RxClkcDlyTg2_u0_p0 @0 {
       bits 6;
       access rw;
       reset 6'h10;
    }
  }
  register RxClkcDlyTg3_u0_p0 @'h93 {
    field RxClkcDlyTg3_u0_p0 @0 {
       bits 6;
       access rw;
       reset 6'h10;
    }
  }
  register Dq0LnSel @'ha0 {
    field Dq0LnSel @0 {
       bits 3;
       access rw;
       reset 3'h0;
    }
  }
  register Dq1LnSel @'ha1 {
    field Dq1LnSel @0 {
       bits 3;
       access rw;
       reset 3'h1;
    }
  }
  register Dq2LnSel @'ha2 {
    field Dq2LnSel @0 {
       bits 3;
       access rw;
       reset 3'h2;
    }
  }
  register Dq3LnSel @'ha3 {
    field Dq3LnSel @0 {
       bits 3;
       access rw;
       reset 3'h3;
    }
  }
  register Dq4LnSel @'ha4 {
    field Dq4LnSel @0 {
       bits 3;
       access rw;
       reset 3'h4;
    }
  }
  register Dq5LnSel @'ha5 {
    field Dq5LnSel @0 {
       bits 3;
       access rw;
       reset 3'h5;
    }
  }
  register Dq6LnSel @'ha6 {
    field Dq6LnSel @0 {
       bits 3;
       access rw;
       reset 3'h6;
    }
  }
  register Dq7LnSel @'ha7 {
    field Dq7LnSel @0 {
       bits 3;
       access rw;
       reset 3'h7;
    }
  }
  register PptCtlStatic @'haa {
    field RFU_PptCtlStatic @0 {
       bits 12;
       access rw;
       reset 12'h0;
    }
  }
  register PptCtlDyn @'hab {
    field RFU_PptCtlDyn @0 {
       bits 2;
       access rw;
       reset 2'h0;
    }
  }
  register PptInfo @'hac {
    field PptInfo @0 {
       bits 16;
       access ro;
       reset 16'h0;
    }
  }
  register PptRxEnEvnt @'had {
    field RFU_PptRxEnEvnt @0 {
       bits 2;
       access rw;
       reset 2'h0;
    }
  }
  register PptDqsCntInvTrnTg0_p0 @'hae {
    field PptDqsCntInvTrnTg0_p0 @0 {
       bits 16;
       access rw;
       reset 16'h0;
    }
  }
  register PptDqsCntInvTrnTg1_p0 @'haf {
    field PptDqsCntInvTrnTg1_p0 @0 {
       bits 16;
       access rw;
       reset 16'h0;
    }
  }
  register DtsmBlankingCtrl @'hb1 {
    field RFU_DtsmBlankingCtrl @0 {
       bits 10;
       access rw;
       reset 10'h0;
    }
  }
  register Tsm0_i0 @'hb2 {
    field RFU_Tsm0_i0 @0 {
       bits 14;
       access rw;
       reset 14'h0;
    }
  }
  register Tsm1_i0 @'hb3 {
    field RFU_Tsm1_i0 @0 {
       bits 16;
       access ro;
       reset 16'h0;
    }
  }
  register Tsm2_i0 @'hb4 {
    field RFU_Tsm2_i0 @0 {
       bits 1;
       access rw;
       reset 1'h0;
    }
  }
  register Tsm3 @'hb5 {
    field RFU_Tsm3 @0 {
       bits 10;
       access rw;
       reset 10'h0;
    }
  }
  register TxChkDataSelects @'hb6 {
    field RFU_TxChkDataSelects @0 {
       bits 2;
       access rw;
       reset 2'h0;
    }
  }
  register DtsmUpThldXingInd @'hb7 {
    field DtsmUpThldXingInd @0 {
       bits 9;
       access ro;
       reset 9'h0;
    }
  }
  register DtsmLoThldXingInd @'hb8 {
    field DtsmLoThldXingInd @0 {
       bits 9;
       access ro;
       reset 9'h0;
    }
  }
  register DbyteAllDtsmCtrl0 @'hb9 {
    field RFU_DbyteAllDtsmCtrl0 @0 {
       bits 9;
       access rw;
       reset 9'h0;
    }
  }
  register DbyteAllDtsmCtrl1 @'hba {
    field RFU_DbyteAllDtsmCtrl1 @0 {
       bits 9;
       access rw;
       reset 9'h0;
    }
  }
  register DbyteAllDtsmCtrl2 @'hbb {
    field RFU_DbyteAllDtsmCtrl2 @0 {
       bits 9;
       access rw;
       reset 9'h0;
    }
  }
  register TxDqDlyTg0_r0_p0 @'hc0 {
    field TxDqDlyTg0_r0_p0 @0 {
       bits 9;
       access rw;
       reset 9'h10;
    }
  }
  register TxDqDlyTg1_r0_p0 @'hc1 {
    field TxDqDlyTg1_r0_p0 @0 {
       bits 9;
       access rw;
       reset 9'h10;
    }
  }
  register TxDqDlyTg2_r0_p0 @'hc2 {
    field TxDqDlyTg2_r0_p0 @0 {
       bits 9;
       access rw;
       reset 9'h10;
    }
  }
  register TxDqDlyTg3_r0_p0 @'hc3 {
    field TxDqDlyTg3_r0_p0 @0 {
       bits 9;
       access rw;
       reset 9'h10;
    }
  }
  register TxDqsDlyTg0_u0_p0 @'hd0 {
    field TxDqsDlyTg0_u0_p0 @0 {
       bits 10;
       access rw;
       reset 10'h100;
    }
  }
  register TxDqsDlyTg1_u0_p0 @'hd1 {
    field TxDqsDlyTg1_u0_p0 @0 {
       bits 10;
       access rw;
       reset 10'h100;
    }
  }
  register TxDqsDlyTg2_u0_p0 @'hd2 {
    field TxDqsDlyTg2_u0_p0 @0 {
       bits 10;
       access rw;
       reset 10'h100;
    }
  }
  register TxDqsDlyTg3_u0_p0 @'hd3 {
    field TxDqsDlyTg3_u0_p0 @0 {
       bits 10;
       access rw;
       reset 10'h100;
    }
  }
  register DxLcdlStatus @'he4 {
    field DxLcdlFineSnapVal @0 {
       bits 10;
       access ro;
       reset 10'h0;
    }
    field DxLcdlPhdSnapVal @10 {
       bits 1;
       access ro;
       reset 1'h0;
    }
    field DxLcdlStickyLock @11 {
       bits 1;
       access ro;
       reset 1'h0;
    }
    field DxLcdlStickyUnlock @12 {
       bits 1;
       access ro;
       reset 1'h0;
    }
    field DxLcdlLiveLock @13 {
       bits 1;
       access ro;
       reset 1'h0;
    }
  }
  register VrefDAC1_r1 @'h130 {
    field VrefDAC1_r1 @0 {
       bits 7;
       access rw;
       reset 7'h0;
    }
  }
  register TrainingCntr_r1 @'h132 {
    field RFU_TrainingCntr_r1 @0 {
       bits 16;
       access rw;
       reset 16'h0;
    }
  }
  register VrefDAC0_r1 @'h140 {
    field VrefDAC0_r1 @0 {
       bits 7;
       access rw;
       reset 7'h0;
    }
  }
  register TxImpedanceCtrl0_b1_p0 @'h141 {
    field DrvStrenDqP @0 {
       bits 6;
       access rw;
       reset 6'h3f;
    }
    field DrvStrenDqN @6 {
       bits 6;
       access rw;
       reset 6'h3f;
    }
  }
  register DqDqsRcvCntrl_b1_p0 @'h143 {
    field SelAnalogVref @0 {
       bits 1;
       access rw;
       reset 1'h0;
    }
    field ExtVrefRange @1 {
       bits 1;
       access rw;
       reset 1'h0;
    }
    field DfeCtrl @2 {
       bits 2;
       access rw;
       reset 2'h0;
    }
    field MajorModeDbyte @4 {
       bits 3;
       access rw;
       reset 3'h3;
    }
    field GainCurrAdj @7 {
       bits 5;
       access rw;
       reset 5'hb;
    }
    field Reserved @12 {
       bits 4;
    }
  }
  register TxImpedanceCtrl1_b1_p0 @'h149 {
    field DrvStrenFSDqP @0 {
       bits 6;
       access rw;
       reset 6'h3f;
    }
    field DrvStrenFSDqN @6 {
       bits 6;
       access rw;
       reset 6'h3f;
    }
  }
  register TxImpedanceCtrl2_b1_p0 @'h14b {
    field DrvStrenEQHiDqP @0 {
       bits 6;
       access rw;
       reset 6'h0;
    }
    field DrvStrenEQLoDqN @6 {
       bits 6;
       access rw;
       reset 6'h0;
    }
  }
  register TxOdtDrvStren_b1_p0 @'h14d {
    field ODTStrenP @0 {
       bits 6;
       access rw;
       reset 6'h0;
    }
    field ODTStrenN @6 {
       bits 6;
       access rw;
       reset 6'h0;
    }
  }
  register TxSlewRate_b1_p0 @'h15f {
    field TxPreP @0 {
       bits 4;
       access rw;
       reset 4'hf;
    }
    field TxPreN @4 {
       bits 4;
       access rw;
       reset 4'hf;
    }
    field TxPreDrvMode @8 {
       bits 3;
       access rw;
       reset 3'h7;
    }
  }
  register TrainingIncDecDtsmEn_r1 @'h162 {
    field TrainingIncDecDtsmEn_r1 @0 {
       bits 9;
       access rw;
       reset 9'h0;
    }
  }
  register RxPBDlyTg0_r1 @'h168 {
    field RxPBDlyTg0_r1 @0 {
       bits 7;
       access rw;
       reset 7'h0;
    }
  }
  register RxPBDlyTg1_r1 @'h169 {
    field RxPBDlyTg1_r1 @0 {
       bits 7;
       access rw;
       reset 7'h0;
    }
  }
  register RxPBDlyTg2_r1 @'h16a {
    field RxPBDlyTg2_r1 @0 {
       bits 7;
       access rw;
       reset 7'h0;
    }
  }
  register RxPBDlyTg3_r1 @'h16b {
    field RxPBDlyTg3_r1 @0 {
       bits 7;
       access rw;
       reset 7'h0;
    }
  }
  register RxEnDlyTg0_u1_p0 @'h180 {
    field RxEnDlyTg0_u1_p0 @0 {
       bits 11;
       access rw;
       reset 11'h100;
    }
  }
  register RxEnDlyTg1_u1_p0 @'h181 {
    field RxEnDlyTg1_u1_p0 @0 {
       bits 11;
       access rw;
       reset 11'h100;
    }
  }
  register RxEnDlyTg2_u1_p0 @'h182 {
    field RxEnDlyTg2_u1_p0 @0 {
       bits 11;
       access rw;
       reset 11'h100;
    }
  }
  register RxEnDlyTg3_u1_p0 @'h183 {
    field RxEnDlyTg3_u1_p0 @0 {
       bits 11;
       access rw;
       reset 11'h100;
    }
  }
  register RxClkDlyTg0_u1_p0 @'h18c {
    field RxClkDlyTg0_u1_p0 @0 {
       bits 6;
       access rw;
       reset 6'h10;
    }
  }
  register RxClkDlyTg1_u1_p0 @'h18d {
    field RxClkDlyTg1_u1_p0 @0 {
       bits 6;
       access rw;
       reset 6'h10;
    }
  }
  register RxClkDlyTg2_u1_p0 @'h18e {
    field RxClkDlyTg2_u1_p0 @0 {
       bits 6;
       access rw;
       reset 6'h10;
    }
  }
  register RxClkDlyTg3_u1_p0 @'h18f {
    field RxClkDlyTg3_u1_p0 @0 {
       bits 6;
       access rw;
       reset 6'h10;
    }
  }
  register RxClkcDlyTg0_u1_p0 @'h190 {
    field RxClkcDlyTg0_u1_p0 @0 {
       bits 6;
       access rw;
       reset 6'h10;
    }
  }
  register RxClkcDlyTg1_u1_p0 @'h191 {
    field RxClkcDlyTg1_u1_p0 @0 {
       bits 6;
       access rw;
       reset 6'h10;
    }
  }
  register RxClkcDlyTg2_u1_p0 @'h192 {
    field RxClkcDlyTg2_u1_p0 @0 {
       bits 6;
       access rw;
       reset 6'h10;
    }
  }
  register RxClkcDlyTg3_u1_p0 @'h193 {
    field RxClkcDlyTg3_u1_p0 @0 {
       bits 6;
       access rw;
       reset 6'h10;
    }
  }
  register Tsm0_i1 @'h1b2 {
    field RFU_Tsm0_i1 @0 {
       bits 14;
       access rw;
       reset 14'h0;
    }
  }
  register Tsm1_i1 @'h1b3 {
    field RFU_Tsm1_i1 @0 {
       bits 16;
       access ro;
       reset 16'h0;
    }
  }
  register Tsm2_i1 @'h1b4 {
    field RFU_Tsm2_i1 @0 {
       bits 1;
       access rw;
       reset 1'h0;
    }
  }
  register TxDqDlyTg0_r1_p0 @'h1c0 {
    field TxDqDlyTg0_r1_p0 @0 {
       bits 9;
       access rw;
       reset 9'h10;
    }
  }
  register TxDqDlyTg1_r1_p0 @'h1c1 {
    field TxDqDlyTg1_r1_p0 @0 {
       bits 9;
       access rw;
       reset 9'h10;
    }
  }
  register TxDqDlyTg2_r1_p0 @'h1c2 {
    field TxDqDlyTg2_r1_p0 @0 {
       bits 9;
       access rw;
       reset 9'h10;
    }
  }
  register TxDqDlyTg3_r1_p0 @'h1c3 {
    field TxDqDlyTg3_r1_p0 @0 {
       bits 9;
       access rw;
       reset 9'h10;
    }
  }
  register TxDqsDlyTg0_u1_p0 @'h1d0 {
    field TxDqsDlyTg0_u1_p0 @0 {
       bits 10;
       access rw;
       reset 10'h100;
    }
  }
  register TxDqsDlyTg1_u1_p0 @'h1d1 {
    field TxDqsDlyTg1_u1_p0 @0 {
       bits 10;
       access rw;
       reset 10'h100;
    }
  }
  register TxDqsDlyTg2_u1_p0 @'h1d2 {
    field TxDqsDlyTg2_u1_p0 @0 {
       bits 10;
       access rw;
       reset 10'h100;
    }
  }
  register TxDqsDlyTg3_u1_p0 @'h1d3 {
    field TxDqsDlyTg3_u1_p0 @0 {
       bits 10;
       access rw;
       reset 10'h100;
    }
  }
  register VrefDAC1_r2 @'h230 {
    field VrefDAC1_r2 @0 {
       bits 7;
       access rw;
       reset 7'h0;
    }
  }
  register TrainingCntr_r2 @'h232 {
    field RFU_TrainingCntr_r2 @0 {
       bits 16;
       access rw;
       reset 16'h0;
    }
  }
  register VrefDAC0_r2 @'h240 {
    field VrefDAC0_r2 @0 {
       bits 7;
       access rw;
       reset 7'h0;
    }
  }
  register TrainingIncDecDtsmEn_r2 @'h262 {
    field TrainingIncDecDtsmEn_r2 @0 {
       bits 9;
       access rw;
       reset 9'h0;
    }
  }
  register RxPBDlyTg0_r2 @'h268 {
    field RxPBDlyTg0_r2 @0 {
       bits 7;
       access rw;
       reset 7'h0;
    }
  }
  register RxPBDlyTg1_r2 @'h269 {
    field RxPBDlyTg1_r2 @0 {
       bits 7;
       access rw;
       reset 7'h0;
    }
  }
  register RxPBDlyTg2_r2 @'h26a {
    field RxPBDlyTg2_r2 @0 {
       bits 7;
       access rw;
       reset 7'h0;
    }
  }
  register RxPBDlyTg3_r2 @'h26b {
    field RxPBDlyTg3_r2 @0 {
       bits 7;
       access rw;
       reset 7'h0;
    }
  }
  register Tsm0_i2 @'h2b2 {
    field RFU_Tsm0_i2 @0 {
       bits 14;
       access rw;
       reset 14'h0;
    }
  }
  register Tsm1_i2 @'h2b3 {
    field RFU_Tsm1_i2 @0 {
       bits 16;
       access ro;
       reset 16'h0;
    }
  }
  register Tsm2_i2 @'h2b4 {
    field RFU_Tsm2_i2 @0 {
       bits 1;
       access rw;
       reset 1'h0;
    }
  }
  register TxDqDlyTg0_r2_p0 @'h2c0 {
    field TxDqDlyTg0_r2_p0 @0 {
       bits 9;
       access rw;
       reset 9'h10;
    }
  }
  register TxDqDlyTg1_r2_p0 @'h2c1 {
    field TxDqDlyTg1_r2_p0 @0 {
       bits 9;
       access rw;
       reset 9'h10;
    }
  }
  register TxDqDlyTg2_r2_p0 @'h2c2 {
    field TxDqDlyTg2_r2_p0 @0 {
       bits 9;
       access rw;
       reset 9'h10;
    }
  }
  register TxDqDlyTg3_r2_p0 @'h2c3 {
    field TxDqDlyTg3_r2_p0 @0 {
       bits 9;
       access rw;
       reset 9'h10;
    }
  }
  register VrefDAC1_r3 @'h330 {
    field VrefDAC1_r3 @0 {
       bits 7;
       access rw;
       reset 7'h0;
    }
  }
  register TrainingCntr_r3 @'h332 {
    field RFU_TrainingCntr_r3 @0 {
       bits 16;
       access rw;
       reset 16'h0;
    }
  }
  register VrefDAC0_r3 @'h340 {
    field VrefDAC0_r3 @0 {
       bits 7;
       access rw;
       reset 7'h0;
    }
  }
  register TrainingIncDecDtsmEn_r3 @'h362 {
    field TrainingIncDecDtsmEn_r3 @0 {
       bits 9;
       access rw;
       reset 9'h0;
    }
  }
  register RxPBDlyTg0_r3 @'h368 {
    field RxPBDlyTg0_r3 @0 {
       bits 7;
       access rw;
       reset 7'h0;
    }
  }
  register RxPBDlyTg1_r3 @'h369 {
    field RxPBDlyTg1_r3 @0 {
       bits 7;
       access rw;
       reset 7'h0;
    }
  }
  register RxPBDlyTg2_r3 @'h36a {
    field RxPBDlyTg2_r3 @0 {
       bits 7;
       access rw;
       reset 7'h0;
    }
  }
  register RxPBDlyTg3_r3 @'h36b {
    field RxPBDlyTg3_r3 @0 {
       bits 7;
       access rw;
       reset 7'h0;
    }
  }
  register Tsm0_i3 @'h3b2 {
    field RFU_Tsm0_i3 @0 {
       bits 14;
       access rw;
       reset 14'h0;
    }
  }
  register Tsm1_i3 @'h3b3 {
    field RFU_Tsm1_i3 @0 {
       bits 16;
       access ro;
       reset 16'h0;
    }
  }
  register Tsm2_i3 @'h3b4 {
    field RFU_Tsm2_i3 @0 {
       bits 1;
       access rw;
       reset 1'h0;
    }
  }
  register TxDqDlyTg0_r3_p0 @'h3c0 {
    field TxDqDlyTg0_r3_p0 @0 {
       bits 9;
       access rw;
       reset 9'h10;
    }
  }
  register TxDqDlyTg1_r3_p0 @'h3c1 {
    field TxDqDlyTg1_r3_p0 @0 {
       bits 9;
       access rw;
       reset 9'h10;
    }
  }
  register TxDqDlyTg2_r3_p0 @'h3c2 {
    field TxDqDlyTg2_r3_p0 @0 {
       bits 9;
       access rw;
       reset 9'h10;
    }
  }
  register TxDqDlyTg3_r3_p0 @'h3c3 {
    field TxDqDlyTg3_r3_p0 @0 {
       bits 9;
       access rw;
       reset 9'h10;
    }
  }
  register VrefDAC1_r4 @'h430 {
    field VrefDAC1_r4 @0 {
       bits 7;
       access rw;
       reset 7'h0;
    }
  }
  register TrainingCntr_r4 @'h432 {
    field RFU_TrainingCntr_r4 @0 {
       bits 16;
       access rw;
       reset 16'h0;
    }
  }
  register VrefDAC0_r4 @'h440 {
    field VrefDAC0_r4 @0 {
       bits 7;
       access rw;
       reset 7'h0;
    }
  }
  register TrainingIncDecDtsmEn_r4 @'h462 {
    field TrainingIncDecDtsmEn_r4 @0 {
       bits 9;
       access rw;
       reset 9'h0;
    }
  }
  register RxPBDlyTg0_r4 @'h468 {
    field RxPBDlyTg0_r4 @0 {
       bits 7;
       access rw;
       reset 7'h0;
    }
  }
  register RxPBDlyTg1_r4 @'h469 {
    field RxPBDlyTg1_r4 @0 {
       bits 7;
       access rw;
       reset 7'h0;
    }
  }
  register RxPBDlyTg2_r4 @'h46a {
    field RxPBDlyTg2_r4 @0 {
       bits 7;
       access rw;
       reset 7'h0;
    }
  }
  register RxPBDlyTg3_r4 @'h46b {
    field RxPBDlyTg3_r4 @0 {
       bits 7;
       access rw;
       reset 7'h0;
    }
  }
  register Tsm0_i4 @'h4b2 {
    field RFU_Tsm0_i4 @0 {
       bits 14;
       access rw;
       reset 14'h0;
    }
  }
  register Tsm1_i4 @'h4b3 {
    field RFU_Tsm1_i4 @0 {
       bits 16;
       access ro;
       reset 16'h0;
    }
  }
  register Tsm2_i4 @'h4b4 {
    field RFU_Tsm2_i4 @0 {
       bits 1;
       access rw;
       reset 1'h0;
    }
  }
  register TxDqDlyTg0_r4_p0 @'h4c0 {
    field TxDqDlyTg0_r4_p0 @0 {
       bits 9;
       access rw;
       reset 9'h10;
    }
  }
  register TxDqDlyTg1_r4_p0 @'h4c1 {
    field TxDqDlyTg1_r4_p0 @0 {
       bits 9;
       access rw;
       reset 9'h10;
    }
  }
  register TxDqDlyTg2_r4_p0 @'h4c2 {
    field TxDqDlyTg2_r4_p0 @0 {
       bits 9;
       access rw;
       reset 9'h10;
    }
  }
  register TxDqDlyTg3_r4_p0 @'h4c3 {
    field TxDqDlyTg3_r4_p0 @0 {
       bits 9;
       access rw;
       reset 9'h10;
    }
  }
  register VrefDAC1_r5 @'h530 {
    field VrefDAC1_r5 @0 {
       bits 7;
       access rw;
       reset 7'h0;
    }
  }
  register TrainingCntr_r5 @'h532 {
    field RFU_TrainingCntr_r5 @0 {
       bits 16;
       access rw;
       reset 16'h0;
    }
  }
  register VrefDAC0_r5 @'h540 {
    field VrefDAC0_r5 @0 {
       bits 7;
       access rw;
       reset 7'h0;
    }
  }
  register TrainingIncDecDtsmEn_r5 @'h562 {
    field TrainingIncDecDtsmEn_r5 @0 {
       bits 9;
       access rw;
       reset 9'h0;
    }
  }
  register RxPBDlyTg0_r5 @'h568 {
    field RxPBDlyTg0_r5 @0 {
       bits 7;
       access rw;
       reset 7'h0;
    }
  }
  register RxPBDlyTg1_r5 @'h569 {
    field RxPBDlyTg1_r5 @0 {
       bits 7;
       access rw;
       reset 7'h0;
    }
  }
  register RxPBDlyTg2_r5 @'h56a {
    field RxPBDlyTg2_r5 @0 {
       bits 7;
       access rw;
       reset 7'h0;
    }
  }
  register RxPBDlyTg3_r5 @'h56b {
    field RxPBDlyTg3_r5 @0 {
       bits 7;
       access rw;
       reset 7'h0;
    }
  }
  register Tsm0_i5 @'h5b2 {
    field RFU_Tsm0_i5 @0 {
       bits 14;
       access rw;
       reset 14'h0;
    }
  }
  register Tsm1_i5 @'h5b3 {
    field RFU_Tsm1_i5 @0 {
       bits 16;
       access ro;
       reset 16'h0;
    }
  }
  register Tsm2_i5 @'h5b4 {
    field RFU_Tsm2_i5 @0 {
       bits 1;
       access rw;
       reset 1'h0;
    }
  }
  register TxDqDlyTg0_r5_p0 @'h5c0 {
    field TxDqDlyTg0_r5_p0 @0 {
       bits 9;
       access rw;
       reset 9'h10;
    }
  }
  register TxDqDlyTg1_r5_p0 @'h5c1 {
    field TxDqDlyTg1_r5_p0 @0 {
       bits 9;
       access rw;
       reset 9'h10;
    }
  }
  register TxDqDlyTg2_r5_p0 @'h5c2 {
    field TxDqDlyTg2_r5_p0 @0 {
       bits 9;
       access rw;
       reset 9'h10;
    }
  }
  register TxDqDlyTg3_r5_p0 @'h5c3 {
    field TxDqDlyTg3_r5_p0 @0 {
       bits 9;
       access rw;
       reset 9'h10;
    }
  }
  register VrefDAC1_r6 @'h630 {
    field VrefDAC1_r6 @0 {
       bits 7;
       access rw;
       reset 7'h0;
    }
  }
  register TrainingCntr_r6 @'h632 {
    field RFU_TrainingCntr_r6 @0 {
       bits 16;
       access rw;
       reset 16'h0;
    }
  }
  register VrefDAC0_r6 @'h640 {
    field VrefDAC0_r6 @0 {
       bits 7;
       access rw;
       reset 7'h0;
    }
  }
  register TrainingIncDecDtsmEn_r6 @'h662 {
    field TrainingIncDecDtsmEn_r6 @0 {
       bits 9;
       access rw;
       reset 9'h0;
    }
  }
  register RxPBDlyTg0_r6 @'h668 {
    field RxPBDlyTg0_r6 @0 {
       bits 7;
       access rw;
       reset 7'h0;
    }
  }
  register RxPBDlyTg1_r6 @'h669 {
    field RxPBDlyTg1_r6 @0 {
       bits 7;
       access rw;
       reset 7'h0;
    }
  }
  register RxPBDlyTg2_r6 @'h66a {
    field RxPBDlyTg2_r6 @0 {
       bits 7;
       access rw;
       reset 7'h0;
    }
  }
  register RxPBDlyTg3_r6 @'h66b {
    field RxPBDlyTg3_r6 @0 {
       bits 7;
       access rw;
       reset 7'h0;
    }
  }
  register Tsm0_i6 @'h6b2 {
    field RFU_Tsm0_i6 @0 {
       bits 14;
       access rw;
       reset 14'h0;
    }
  }
  register Tsm1_i6 @'h6b3 {
    field RFU_Tsm1_i6 @0 {
       bits 16;
       access ro;
       reset 16'h0;
    }
  }
  register Tsm2_i6 @'h6b4 {
    field RFU_Tsm2_i6 @0 {
       bits 1;
       access rw;
       reset 1'h0;
    }
  }
  register TxDqDlyTg0_r6_p0 @'h6c0 {
    field TxDqDlyTg0_r6_p0 @0 {
       bits 9;
       access rw;
       reset 9'h10;
    }
  }
  register TxDqDlyTg1_r6_p0 @'h6c1 {
    field TxDqDlyTg1_r6_p0 @0 {
       bits 9;
       access rw;
       reset 9'h10;
    }
  }
  register TxDqDlyTg2_r6_p0 @'h6c2 {
    field TxDqDlyTg2_r6_p0 @0 {
       bits 9;
       access rw;
       reset 9'h10;
    }
  }
  register TxDqDlyTg3_r6_p0 @'h6c3 {
    field TxDqDlyTg3_r6_p0 @0 {
       bits 9;
       access rw;
       reset 9'h10;
    }
  }
  register VrefDAC1_r7 @'h730 {
    field VrefDAC1_r7 @0 {
       bits 7;
       access rw;
       reset 7'h0;
    }
  }
  register TrainingCntr_r7 @'h732 {
    field RFU_TrainingCntr_r7 @0 {
       bits 16;
       access rw;
       reset 16'h0;
    }
  }
  register VrefDAC0_r7 @'h740 {
    field VrefDAC0_r7 @0 {
       bits 7;
       access rw;
       reset 7'h0;
    }
  }
  register TrainingIncDecDtsmEn_r7 @'h762 {
    field TrainingIncDecDtsmEn_r7 @0 {
       bits 9;
       access rw;
       reset 9'h0;
    }
  }
  register RxPBDlyTg0_r7 @'h768 {
    field RxPBDlyTg0_r7 @0 {
       bits 7;
       access rw;
       reset 7'h0;
    }
  }
  register RxPBDlyTg1_r7 @'h769 {
    field RxPBDlyTg1_r7 @0 {
       bits 7;
       access rw;
       reset 7'h0;
    }
  }
  register RxPBDlyTg2_r7 @'h76a {
    field RxPBDlyTg2_r7 @0 {
       bits 7;
       access rw;
       reset 7'h0;
    }
  }
  register RxPBDlyTg3_r7 @'h76b {
    field RxPBDlyTg3_r7 @0 {
       bits 7;
       access rw;
       reset 7'h0;
    }
  }
  register Tsm0_i7 @'h7b2 {
    field RFU_Tsm0_i7 @0 {
       bits 14;
       access rw;
       reset 14'h0;
    }
  }
  register Tsm1_i7 @'h7b3 {
    field RFU_Tsm1_i7 @0 {
       bits 16;
       access ro;
       reset 16'h0;
    }
  }
  register Tsm2_i7 @'h7b4 {
    field RFU_Tsm2_i7 @0 {
       bits 1;
       access rw;
       reset 1'h0;
    }
  }
  register TxDqDlyTg0_r7_p0 @'h7c0 {
    field TxDqDlyTg0_r7_p0 @0 {
       bits 9;
       access rw;
       reset 9'h10;
    }
  }
  register TxDqDlyTg1_r7_p0 @'h7c1 {
    field TxDqDlyTg1_r7_p0 @0 {
       bits 9;
       access rw;
       reset 9'h10;
    }
  }
  register TxDqDlyTg2_r7_p0 @'h7c2 {
    field TxDqDlyTg2_r7_p0 @0 {
       bits 9;
       access rw;
       reset 9'h10;
    }
  }
  register TxDqDlyTg3_r7_p0 @'h7c3 {
    field TxDqDlyTg3_r7_p0 @0 {
       bits 9;
       access rw;
       reset 9'h10;
    }
  }
  register VrefDAC1_r8 @'h830 {
    field VrefDAC1_r8 @0 {
       bits 7;
       access rw;
       reset 7'h0;
    }
  }
  register TrainingCntr_r8 @'h832 {
    field RFU_TrainingCntr_r8 @0 {
       bits 16;
       access rw;
       reset 16'h0;
    }
  }
  register VrefDAC0_r8 @'h840 {
    field VrefDAC0_r8 @0 {
       bits 7;
       access rw;
       reset 7'h0;
    }
  }
  register TrainingIncDecDtsmEn_r8 @'h862 {
    field TrainingIncDecDtsmEn_r8 @0 {
       bits 9;
       access rw;
       reset 9'h0;
    }
  }
  register RxPBDlyTg0_r8 @'h868 {
    field RxPBDlyTg0_r8 @0 {
       bits 7;
       access rw;
       reset 7'h0;
    }
  }
  register RxPBDlyTg1_r8 @'h869 {
    field RxPBDlyTg1_r8 @0 {
       bits 7;
       access rw;
       reset 7'h0;
    }
  }
  register RxPBDlyTg2_r8 @'h86a {
    field RxPBDlyTg2_r8 @0 {
       bits 7;
       access rw;
       reset 7'h0;
    }
  }
  register RxPBDlyTg3_r8 @'h86b {
    field RxPBDlyTg3_r8 @0 {
       bits 7;
       access rw;
       reset 7'h0;
    }
  }
  register Tsm0_i8 @'h8b2 {
    field RFU_Tsm0_i8 @0 {
       bits 14;
       access rw;
       reset 14'h0;
    }
  }
  register Tsm1_i8 @'h8b3 {
    field RFU_Tsm1_i8 @0 {
       bits 16;
       access ro;
       reset 16'h0;
    }
  }
  register Tsm2_i8 @'h8b4 {
    field RFU_Tsm2_i8 @0 {
       bits 1;
       access rw;
       reset 1'h0;
    }
  }
  register TxDqDlyTg0_r8_p0 @'h8c0 {
    field TxDqDlyTg0_r8_p0 @0 {
       bits 9;
       access rw;
       reset 9'h10;
    }
  }
  register TxDqDlyTg1_r8_p0 @'h8c1 {
    field TxDqDlyTg1_r8_p0 @0 {
       bits 9;
       access rw;
       reset 9'h10;
    }
  }
  register TxDqDlyTg2_r8_p0 @'h8c2 {
    field TxDqDlyTg2_r8_p0 @0 {
       bits 9;
       access rw;
       reset 9'h10;
    }
  }
  register TxDqDlyTg3_r8_p0 @'h8c3 {
    field TxDqDlyTg3_r8_p0 @0 {
       bits 9;
       access rw;
       reset 9'h10;
    }
  }
  register UseDqsEnReplica_p1 @'h100003 {
    field UseDqsEnReplica_p1 @0 {
       bits 1;
       access rw;
       reset 1'h0;
    }
  }
  register DFIMRL_p1 @'h100020 {
    field DFIMRL_p1 @0 {
       bits 5;
       access rw;
       reset 5'h6;
    }
  }
  register TxImpedanceCtrl0_b0_p1 @'h100041 {
    field DrvStrenDqP @0 {
       bits 6;
       access rw;
       reset 6'h3f;
    }
    field DrvStrenDqN @6 {
       bits 6;
       access rw;
       reset 6'h3f;
    }
  }
  register DqDqsRcvCntrl_b0_p1 @'h100043 {
    field SelAnalogVref @0 {
       bits 1;
       access rw;
       reset 1'h0;
    }
    field ExtVrefRange @1 {
       bits 1;
       access rw;
       reset 1'h0;
    }
    field DfeCtrl @2 {
       bits 2;
       access rw;
       reset 2'h0;
    }
    field MajorModeDbyte @4 {
       bits 3;
       access rw;
       reset 3'h3;
    }
    field GainCurrAdj @7 {
       bits 5;
       access rw;
       reset 5'hb;
    }
    field Reserved @12 {
       bits 4;
    }
  }
  register TxEqualizationMode_p1 @'h100048 {
    field TxEqMode @0 {
       bits 2;
       access rw;
       reset 2'h0;
    }
  }
  register TxImpedanceCtrl1_b0_p1 @'h100049 {
    field DrvStrenFSDqP @0 {
       bits 6;
       access rw;
       reset 6'h3f;
    }
    field DrvStrenFSDqN @6 {
       bits 6;
       access rw;
       reset 6'h3f;
    }
  }
  register TxImpedanceCtrl2_b0_p1 @'h10004b {
    field DrvStrenEQHiDqP @0 {
       bits 6;
       access rw;
       reset 6'h0;
    }
    field DrvStrenEQLoDqN @6 {
       bits 6;
       access rw;
       reset 6'h0;
    }
  }
  register DqDqsRcvCntrl2_p1 @'h10004c {
    field EnRxAgressivePDR @0 {
       bits 1;
       access rw;
       reset 1'h0;
    }
  }
  register TxOdtDrvStren_b0_p1 @'h10004d {
    field ODTStrenP @0 {
       bits 6;
       access rw;
       reset 6'h0;
    }
    field ODTStrenN @6 {
       bits 6;
       access rw;
       reset 6'h0;
    }
  }
  register TxSlewRate_b0_p1 @'h10005f {
    field TxPreP @0 {
       bits 4;
       access rw;
       reset 4'hf;
    }
    field TxPreN @4 {
       bits 4;
       access rw;
       reset 4'hf;
    }
    field TxPreDrvMode @8 {
       bits 3;
       access rw;
       reset 3'h7;
    }
  }
  register RxEnDlyTg0_u0_p1 @'h100080 {
    field RxEnDlyTg0_u0_p1 @0 {
       bits 11;
       access rw;
       reset 11'h100;
    }
  }
  register RxEnDlyTg1_u0_p1 @'h100081 {
    field RxEnDlyTg1_u0_p1 @0 {
       bits 11;
       access rw;
       reset 11'h100;
    }
  }
  register RxEnDlyTg2_u0_p1 @'h100082 {
    field RxEnDlyTg2_u0_p1 @0 {
       bits 11;
       access rw;
       reset 11'h100;
    }
  }
  register RxEnDlyTg3_u0_p1 @'h100083 {
    field RxEnDlyTg3_u0_p1 @0 {
       bits 11;
       access rw;
       reset 11'h100;
    }
  }
  register RxClkDlyTg0_u0_p1 @'h10008c {
    field RxClkDlyTg0_u0_p1 @0 {
       bits 6;
       access rw;
       reset 6'h10;
    }
  }
  register RxClkDlyTg1_u0_p1 @'h10008d {
    field RxClkDlyTg1_u0_p1 @0 {
       bits 6;
       access rw;
       reset 6'h10;
    }
  }
  register RxClkDlyTg2_u0_p1 @'h10008e {
    field RxClkDlyTg2_u0_p1 @0 {
       bits 6;
       access rw;
       reset 6'h10;
    }
  }
  register RxClkDlyTg3_u0_p1 @'h10008f {
    field RxClkDlyTg3_u0_p1 @0 {
       bits 6;
       access rw;
       reset 6'h10;
    }
  }
  register RxClkcDlyTg0_u0_p1 @'h100090 {
    field RxClkcDlyTg0_u0_p1 @0 {
       bits 6;
       access rw;
       reset 6'h10;
    }
  }
  register RxClkcDlyTg1_u0_p1 @'h100091 {
    field RxClkcDlyTg1_u0_p1 @0 {
       bits 6;
       access rw;
       reset 6'h10;
    }
  }
  register RxClkcDlyTg2_u0_p1 @'h100092 {
    field RxClkcDlyTg2_u0_p1 @0 {
       bits 6;
       access rw;
       reset 6'h10;
    }
  }
  register RxClkcDlyTg3_u0_p1 @'h100093 {
    field RxClkcDlyTg3_u0_p1 @0 {
       bits 6;
       access rw;
       reset 6'h10;
    }
  }
  register PptDqsCntInvTrnTg0_p1 @'h1000ae {
    field PptDqsCntInvTrnTg0_p1 @0 {
       bits 16;
       access rw;
       reset 16'h0;
    }
  }
  register PptDqsCntInvTrnTg1_p1 @'h1000af {
    field PptDqsCntInvTrnTg1_p1 @0 {
       bits 16;
       access rw;
       reset 16'h0;
    }
  }
  register TxDqDlyTg0_r0_p1 @'h1000c0 {
    field TxDqDlyTg0_r0_p1 @0 {
       bits 9;
       access rw;
       reset 9'h10;
    }
  }
  register TxDqDlyTg1_r0_p1 @'h1000c1 {
    field TxDqDlyTg1_r0_p1 @0 {
       bits 9;
       access rw;
       reset 9'h10;
    }
  }
  register TxDqDlyTg2_r0_p1 @'h1000c2 {
    field TxDqDlyTg2_r0_p1 @0 {
       bits 9;
       access rw;
       reset 9'h10;
    }
  }
  register TxDqDlyTg3_r0_p1 @'h1000c3 {
    field TxDqDlyTg3_r0_p1 @0 {
       bits 9;
       access rw;
       reset 9'h10;
    }
  }
  register TxDqsDlyTg0_u0_p1 @'h1000d0 {
    field TxDqsDlyTg0_u0_p1 @0 {
       bits 10;
       access rw;
       reset 10'h100;
    }
  }
  register TxDqsDlyTg1_u0_p1 @'h1000d1 {
    field TxDqsDlyTg1_u0_p1 @0 {
       bits 10;
       access rw;
       reset 10'h100;
    }
  }
  register TxDqsDlyTg2_u0_p1 @'h1000d2 {
    field TxDqsDlyTg2_u0_p1 @0 {
       bits 10;
       access rw;
       reset 10'h100;
    }
  }
  register TxDqsDlyTg3_u0_p1 @'h1000d3 {
    field TxDqsDlyTg3_u0_p1 @0 {
       bits 10;
       access rw;
       reset 10'h100;
    }
  }
  register TxImpedanceCtrl0_b1_p1 @'h100141 {
    field DrvStrenDqP @0 {
       bits 6;
       access rw;
       reset 6'h3f;
    }
    field DrvStrenDqN @6 {
       bits 6;
       access rw;
       reset 6'h3f;
    }
  }
  register DqDqsRcvCntrl_b1_p1 @'h100143 {
    field SelAnalogVref @0 {
       bits 1;
       access rw;
       reset 1'h0;
    }
    field ExtVrefRange @1 {
       bits 1;
       access rw;
       reset 1'h0;
    }
    field DfeCtrl @2 {
       bits 2;
       access rw;
       reset 2'h0;
    }
    field MajorModeDbyte @4 {
       bits 3;
       access rw;
       reset 3'h3;
    }
    field GainCurrAdj @7 {
       bits 5;
       access rw;
       reset 5'hb;
    }
    field Reserved @12 {
       bits 4;
    }
  }
  register TxImpedanceCtrl1_b1_p1 @'h100149 {
    field DrvStrenFSDqP @0 {
       bits 6;
       access rw;
       reset 6'h3f;
    }
    field DrvStrenFSDqN @6 {
       bits 6;
       access rw;
       reset 6'h3f;
    }
  }
  register TxImpedanceCtrl2_b1_p1 @'h10014b {
    field DrvStrenEQHiDqP @0 {
       bits 6;
       access rw;
       reset 6'h0;
    }
    field DrvStrenEQLoDqN @6 {
       bits 6;
       access rw;
       reset 6'h0;
    }
  }
  register TxOdtDrvStren_b1_p1 @'h10014d {
    field ODTStrenP @0 {
       bits 6;
       access rw;
       reset 6'h0;
    }
    field ODTStrenN @6 {
       bits 6;
       access rw;
       reset 6'h0;
    }
  }
  register TxSlewRate_b1_p1 @'h10015f {
    field TxPreP @0 {
       bits 4;
       access rw;
       reset 4'hf;
    }
    field TxPreN @4 {
       bits 4;
       access rw;
       reset 4'hf;
    }
    field TxPreDrvMode @8 {
       bits 3;
       access rw;
       reset 3'h7;
    }
  }
  register RxEnDlyTg0_u1_p1 @'h100180 {
    field RxEnDlyTg0_u1_p1 @0 {
       bits 11;
       access rw;
       reset 11'h100;
    }
  }
  register RxEnDlyTg1_u1_p1 @'h100181 {
    field RxEnDlyTg1_u1_p1 @0 {
       bits 11;
       access rw;
       reset 11'h100;
    }
  }
  register RxEnDlyTg2_u1_p1 @'h100182 {
    field RxEnDlyTg2_u1_p1 @0 {
       bits 11;
       access rw;
       reset 11'h100;
    }
  }
  register RxEnDlyTg3_u1_p1 @'h100183 {
    field RxEnDlyTg3_u1_p1 @0 {
       bits 11;
       access rw;
       reset 11'h100;
    }
  }
  register RxClkDlyTg0_u1_p1 @'h10018c {
    field RxClkDlyTg0_u1_p1 @0 {
       bits 6;
       access rw;
       reset 6'h10;
    }
  }
  register RxClkDlyTg1_u1_p1 @'h10018d {
    field RxClkDlyTg1_u1_p1 @0 {
       bits 6;
       access rw;
       reset 6'h10;
    }
  }
  register RxClkDlyTg2_u1_p1 @'h10018e {
    field RxClkDlyTg2_u1_p1 @0 {
       bits 6;
       access rw;
       reset 6'h10;
    }
  }
  register RxClkDlyTg3_u1_p1 @'h10018f {
    field RxClkDlyTg3_u1_p1 @0 {
       bits 6;
       access rw;
       reset 6'h10;
    }
  }
  register RxClkcDlyTg0_u1_p1 @'h100190 {
    field RxClkcDlyTg0_u1_p1 @0 {
       bits 6;
       access rw;
       reset 6'h10;
    }
  }
  register RxClkcDlyTg1_u1_p1 @'h100191 {
    field RxClkcDlyTg1_u1_p1 @0 {
       bits 6;
       access rw;
       reset 6'h10;
    }
  }
  register RxClkcDlyTg2_u1_p1 @'h100192 {
    field RxClkcDlyTg2_u1_p1 @0 {
       bits 6;
       access rw;
       reset 6'h10;
    }
  }
  register RxClkcDlyTg3_u1_p1 @'h100193 {
    field RxClkcDlyTg3_u1_p1 @0 {
       bits 6;
       access rw;
       reset 6'h10;
    }
  }
  register TxDqDlyTg0_r1_p1 @'h1001c0 {
    field TxDqDlyTg0_r1_p1 @0 {
       bits 9;
       access rw;
       reset 9'h10;
    }
  }
  register TxDqDlyTg1_r1_p1 @'h1001c1 {
    field TxDqDlyTg1_r1_p1 @0 {
       bits 9;
       access rw;
       reset 9'h10;
    }
  }
  register TxDqDlyTg2_r1_p1 @'h1001c2 {
    field TxDqDlyTg2_r1_p1 @0 {
       bits 9;
       access rw;
       reset 9'h10;
    }
  }
  register TxDqDlyTg3_r1_p1 @'h1001c3 {
    field TxDqDlyTg3_r1_p1 @0 {
       bits 9;
       access rw;
       reset 9'h10;
    }
  }
  register TxDqsDlyTg0_u1_p1 @'h1001d0 {
    field TxDqsDlyTg0_u1_p1 @0 {
       bits 10;
       access rw;
       reset 10'h100;
    }
  }
  register TxDqsDlyTg1_u1_p1 @'h1001d1 {
    field TxDqsDlyTg1_u1_p1 @0 {
       bits 10;
       access rw;
       reset 10'h100;
    }
  }
  register TxDqsDlyTg2_u1_p1 @'h1001d2 {
    field TxDqsDlyTg2_u1_p1 @0 {
       bits 10;
       access rw;
       reset 10'h100;
    }
  }
  register TxDqsDlyTg3_u1_p1 @'h1001d3 {
    field TxDqsDlyTg3_u1_p1 @0 {
       bits 10;
       access rw;
       reset 10'h100;
    }
  }
  register TxDqDlyTg0_r2_p1 @'h1002c0 {
    field TxDqDlyTg0_r2_p1 @0 {
       bits 9;
       access rw;
       reset 9'h10;
    }
  }
  register TxDqDlyTg1_r2_p1 @'h1002c1 {
    field TxDqDlyTg1_r2_p1 @0 {
       bits 9;
       access rw;
       reset 9'h10;
    }
  }
  register TxDqDlyTg2_r2_p1 @'h1002c2 {
    field TxDqDlyTg2_r2_p1 @0 {
       bits 9;
       access rw;
       reset 9'h10;
    }
  }
  register TxDqDlyTg3_r2_p1 @'h1002c3 {
    field TxDqDlyTg3_r2_p1 @0 {
       bits 9;
       access rw;
       reset 9'h10;
    }
  }
  register TxDqDlyTg0_r3_p1 @'h1003c0 {
    field TxDqDlyTg0_r3_p1 @0 {
       bits 9;
       access rw;
       reset 9'h10;
    }
  }
  register TxDqDlyTg1_r3_p1 @'h1003c1 {
    field TxDqDlyTg1_r3_p1 @0 {
       bits 9;
       access rw;
       reset 9'h10;
    }
  }
  register TxDqDlyTg2_r3_p1 @'h1003c2 {
    field TxDqDlyTg2_r3_p1 @0 {
       bits 9;
       access rw;
       reset 9'h10;
    }
  }
  register TxDqDlyTg3_r3_p1 @'h1003c3 {
    field TxDqDlyTg3_r3_p1 @0 {
       bits 9;
       access rw;
       reset 9'h10;
    }
  }
  register TxDqDlyTg0_r4_p1 @'h1004c0 {
    field TxDqDlyTg0_r4_p1 @0 {
       bits 9;
       access rw;
       reset 9'h10;
    }
  }
  register TxDqDlyTg1_r4_p1 @'h1004c1 {
    field TxDqDlyTg1_r4_p1 @0 {
       bits 9;
       access rw;
       reset 9'h10;
    }
  }
  register TxDqDlyTg2_r4_p1 @'h1004c2 {
    field TxDqDlyTg2_r4_p1 @0 {
       bits 9;
       access rw;
       reset 9'h10;
    }
  }
  register TxDqDlyTg3_r4_p1 @'h1004c3 {
    field TxDqDlyTg3_r4_p1 @0 {
       bits 9;
       access rw;
       reset 9'h10;
    }
  }
  register TxDqDlyTg0_r5_p1 @'h1005c0 {
    field TxDqDlyTg0_r5_p1 @0 {
       bits 9;
       access rw;
       reset 9'h10;
    }
  }
  register TxDqDlyTg1_r5_p1 @'h1005c1 {
    field TxDqDlyTg1_r5_p1 @0 {
       bits 9;
       access rw;
       reset 9'h10;
    }
  }
  register TxDqDlyTg2_r5_p1 @'h1005c2 {
    field TxDqDlyTg2_r5_p1 @0 {
       bits 9;
       access rw;
       reset 9'h10;
    }
  }
  register TxDqDlyTg3_r5_p1 @'h1005c3 {
    field TxDqDlyTg3_r5_p1 @0 {
       bits 9;
       access rw;
       reset 9'h10;
    }
  }
  register TxDqDlyTg0_r6_p1 @'h1006c0 {
    field TxDqDlyTg0_r6_p1 @0 {
       bits 9;
       access rw;
       reset 9'h10;
    }
  }
  register TxDqDlyTg1_r6_p1 @'h1006c1 {
    field TxDqDlyTg1_r6_p1 @0 {
       bits 9;
       access rw;
       reset 9'h10;
    }
  }
  register TxDqDlyTg2_r6_p1 @'h1006c2 {
    field TxDqDlyTg2_r6_p1 @0 {
       bits 9;
       access rw;
       reset 9'h10;
    }
  }
  register TxDqDlyTg3_r6_p1 @'h1006c3 {
    field TxDqDlyTg3_r6_p1 @0 {
       bits 9;
       access rw;
       reset 9'h10;
    }
  }
  register TxDqDlyTg0_r7_p1 @'h1007c0 {
    field TxDqDlyTg0_r7_p1 @0 {
       bits 9;
       access rw;
       reset 9'h10;
    }
  }
  register TxDqDlyTg1_r7_p1 @'h1007c1 {
    field TxDqDlyTg1_r7_p1 @0 {
       bits 9;
       access rw;
       reset 9'h10;
    }
  }
  register TxDqDlyTg2_r7_p1 @'h1007c2 {
    field TxDqDlyTg2_r7_p1 @0 {
       bits 9;
       access rw;
       reset 9'h10;
    }
  }
  register TxDqDlyTg3_r7_p1 @'h1007c3 {
    field TxDqDlyTg3_r7_p1 @0 {
       bits 9;
       access rw;
       reset 9'h10;
    }
  }
  register TxDqDlyTg0_r8_p1 @'h1008c0 {
    field TxDqDlyTg0_r8_p1 @0 {
       bits 9;
       access rw;
       reset 9'h10;
    }
  }
  register TxDqDlyTg1_r8_p1 @'h1008c1 {
    field TxDqDlyTg1_r8_p1 @0 {
       bits 9;
       access rw;
       reset 9'h10;
    }
  }
  register TxDqDlyTg2_r8_p1 @'h1008c2 {
    field TxDqDlyTg2_r8_p1 @0 {
       bits 9;
       access rw;
       reset 9'h10;
    }
  }
  register TxDqDlyTg3_r8_p1 @'h1008c3 {
    field TxDqDlyTg3_r8_p1 @0 {
       bits 9;
       access rw;
       reset 9'h10;
    }
  }
  register UseDqsEnReplica_p2 @'h200003 {
    field UseDqsEnReplica_p2 @0 {
       bits 1;
       access rw;
       reset 1'h0;
    }
  }
  register DFIMRL_p2 @'h200020 {
    field DFIMRL_p2 @0 {
       bits 5;
       access rw;
       reset 5'h6;
    }
  }
  register TxImpedanceCtrl0_b0_p2 @'h200041 {
    field DrvStrenDqP @0 {
       bits 6;
       access rw;
       reset 6'h3f;
    }
    field DrvStrenDqN @6 {
       bits 6;
       access rw;
       reset 6'h3f;
    }
  }
  register DqDqsRcvCntrl_b0_p2 @'h200043 {
    field SelAnalogVref @0 {
       bits 1;
       access rw;
       reset 1'h0;
    }
    field ExtVrefRange @1 {
       bits 1;
       access rw;
       reset 1'h0;
    }
    field DfeCtrl @2 {
       bits 2;
       access rw;
       reset 2'h0;
    }
    field MajorModeDbyte @4 {
       bits 3;
       access rw;
       reset 3'h3;
    }
    field GainCurrAdj @7 {
       bits 5;
       access rw;
       reset 5'hb;
    }
    field Reserved @12 {
       bits 4;
    }
  }
  register TxEqualizationMode_p2 @'h200048 {
    field TxEqMode @0 {
       bits 2;
       access rw;
       reset 2'h0;
    }
  }
  register TxImpedanceCtrl1_b0_p2 @'h200049 {
    field DrvStrenFSDqP @0 {
       bits 6;
       access rw;
       reset 6'h3f;
    }
    field DrvStrenFSDqN @6 {
       bits 6;
       access rw;
       reset 6'h3f;
    }
  }
  register TxImpedanceCtrl2_b0_p2 @'h20004b {
    field DrvStrenEQHiDqP @0 {
       bits 6;
       access rw;
       reset 6'h0;
    }
    field DrvStrenEQLoDqN @6 {
       bits 6;
       access rw;
       reset 6'h0;
    }
  }
  register DqDqsRcvCntrl2_p2 @'h20004c {
    field EnRxAgressivePDR @0 {
       bits 1;
       access rw;
       reset 1'h0;
    }
  }
  register TxOdtDrvStren_b0_p2 @'h20004d {
    field ODTStrenP @0 {
       bits 6;
       access rw;
       reset 6'h0;
    }
    field ODTStrenN @6 {
       bits 6;
       access rw;
       reset 6'h0;
    }
  }
  register TxSlewRate_b0_p2 @'h20005f {
    field TxPreP @0 {
       bits 4;
       access rw;
       reset 4'hf;
    }
    field TxPreN @4 {
       bits 4;
       access rw;
       reset 4'hf;
    }
    field TxPreDrvMode @8 {
       bits 3;
       access rw;
       reset 3'h7;
    }
  }
  register RxEnDlyTg0_u0_p2 @'h200080 {
    field RxEnDlyTg0_u0_p2 @0 {
       bits 11;
       access rw;
       reset 11'h100;
    }
  }
  register RxEnDlyTg1_u0_p2 @'h200081 {
    field RxEnDlyTg1_u0_p2 @0 {
       bits 11;
       access rw;
       reset 11'h100;
    }
  }
  register RxEnDlyTg2_u0_p2 @'h200082 {
    field RxEnDlyTg2_u0_p2 @0 {
       bits 11;
       access rw;
       reset 11'h100;
    }
  }
  register RxEnDlyTg3_u0_p2 @'h200083 {
    field RxEnDlyTg3_u0_p2 @0 {
       bits 11;
       access rw;
       reset 11'h100;
    }
  }
  register RxClkDlyTg0_u0_p2 @'h20008c {
    field RxClkDlyTg0_u0_p2 @0 {
       bits 6;
       access rw;
       reset 6'h10;
    }
  }
  register RxClkDlyTg1_u0_p2 @'h20008d {
    field RxClkDlyTg1_u0_p2 @0 {
       bits 6;
       access rw;
       reset 6'h10;
    }
  }
  register RxClkDlyTg2_u0_p2 @'h20008e {
    field RxClkDlyTg2_u0_p2 @0 {
       bits 6;
       access rw;
       reset 6'h10;
    }
  }
  register RxClkDlyTg3_u0_p2 @'h20008f {
    field RxClkDlyTg3_u0_p2 @0 {
       bits 6;
       access rw;
       reset 6'h10;
    }
  }
  register RxClkcDlyTg0_u0_p2 @'h200090 {
    field RxClkcDlyTg0_u0_p2 @0 {
       bits 6;
       access rw;
       reset 6'h10;
    }
  }
  register RxClkcDlyTg1_u0_p2 @'h200091 {
    field RxClkcDlyTg1_u0_p2 @0 {
       bits 6;
       access rw;
       reset 6'h10;
    }
  }
  register RxClkcDlyTg2_u0_p2 @'h200092 {
    field RxClkcDlyTg2_u0_p2 @0 {
       bits 6;
       access rw;
       reset 6'h10;
    }
  }
  register RxClkcDlyTg3_u0_p2 @'h200093 {
    field RxClkcDlyTg3_u0_p2 @0 {
       bits 6;
       access rw;
       reset 6'h10;
    }
  }
  register PptDqsCntInvTrnTg0_p2 @'h2000ae {
    field PptDqsCntInvTrnTg0_p2 @0 {
       bits 16;
       access rw;
       reset 16'h0;
    }
  }
  register PptDqsCntInvTrnTg1_p2 @'h2000af {
    field PptDqsCntInvTrnTg1_p2 @0 {
       bits 16;
       access rw;
       reset 16'h0;
    }
  }
  register TxDqDlyTg0_r0_p2 @'h2000c0 {
    field TxDqDlyTg0_r0_p2 @0 {
       bits 9;
       access rw;
       reset 9'h10;
    }
  }
  register TxDqDlyTg1_r0_p2 @'h2000c1 {
    field TxDqDlyTg1_r0_p2 @0 {
       bits 9;
       access rw;
       reset 9'h10;
    }
  }
  register TxDqDlyTg2_r0_p2 @'h2000c2 {
    field TxDqDlyTg2_r0_p2 @0 {
       bits 9;
       access rw;
       reset 9'h10;
    }
  }
  register TxDqDlyTg3_r0_p2 @'h2000c3 {
    field TxDqDlyTg3_r0_p2 @0 {
       bits 9;
       access rw;
       reset 9'h10;
    }
  }
  register TxDqsDlyTg0_u0_p2 @'h2000d0 {
    field TxDqsDlyTg0_u0_p2 @0 {
       bits 10;
       access rw;
       reset 10'h100;
    }
  }
  register TxDqsDlyTg1_u0_p2 @'h2000d1 {
    field TxDqsDlyTg1_u0_p2 @0 {
       bits 10;
       access rw;
       reset 10'h100;
    }
  }
  register TxDqsDlyTg2_u0_p2 @'h2000d2 {
    field TxDqsDlyTg2_u0_p2 @0 {
       bits 10;
       access rw;
       reset 10'h100;
    }
  }
  register TxDqsDlyTg3_u0_p2 @'h2000d3 {
    field TxDqsDlyTg3_u0_p2 @0 {
       bits 10;
       access rw;
       reset 10'h100;
    }
  }
  register TxImpedanceCtrl0_b1_p2 @'h200141 {
    field DrvStrenDqP @0 {
       bits 6;
       access rw;
       reset 6'h3f;
    }
    field DrvStrenDqN @6 {
       bits 6;
       access rw;
       reset 6'h3f;
    }
  }
  register DqDqsRcvCntrl_b1_p2 @'h200143 {
    field SelAnalogVref @0 {
       bits 1;
       access rw;
       reset 1'h0;
    }
    field ExtVrefRange @1 {
       bits 1;
       access rw;
       reset 1'h0;
    }
    field DfeCtrl @2 {
       bits 2;
       access rw;
       reset 2'h0;
    }
    field MajorModeDbyte @4 {
       bits 3;
       access rw;
       reset 3'h3;
    }
    field GainCurrAdj @7 {
       bits 5;
       access rw;
       reset 5'hb;
    }
    field Reserved @12 {
       bits 4;
    }
  }
  register TxImpedanceCtrl1_b1_p2 @'h200149 {
    field DrvStrenFSDqP @0 {
       bits 6;
       access rw;
       reset 6'h3f;
    }
    field DrvStrenFSDqN @6 {
       bits 6;
       access rw;
       reset 6'h3f;
    }
  }
  register TxImpedanceCtrl2_b1_p2 @'h20014b {
    field DrvStrenEQHiDqP @0 {
       bits 6;
       access rw;
       reset 6'h0;
    }
    field DrvStrenEQLoDqN @6 {
       bits 6;
       access rw;
       reset 6'h0;
    }
  }
  register TxOdtDrvStren_b1_p2 @'h20014d {
    field ODTStrenP @0 {
       bits 6;
       access rw;
       reset 6'h0;
    }
    field ODTStrenN @6 {
       bits 6;
       access rw;
       reset 6'h0;
    }
  }
  register TxSlewRate_b1_p2 @'h20015f {
    field TxPreP @0 {
       bits 4;
       access rw;
       reset 4'hf;
    }
    field TxPreN @4 {
       bits 4;
       access rw;
       reset 4'hf;
    }
    field TxPreDrvMode @8 {
       bits 3;
       access rw;
       reset 3'h7;
    }
  }
  register RxEnDlyTg0_u1_p2 @'h200180 {
    field RxEnDlyTg0_u1_p2 @0 {
       bits 11;
       access rw;
       reset 11'h100;
    }
  }
  register RxEnDlyTg1_u1_p2 @'h200181 {
    field RxEnDlyTg1_u1_p2 @0 {
       bits 11;
       access rw;
       reset 11'h100;
    }
  }
  register RxEnDlyTg2_u1_p2 @'h200182 {
    field RxEnDlyTg2_u1_p2 @0 {
       bits 11;
       access rw;
       reset 11'h100;
    }
  }
  register RxEnDlyTg3_u1_p2 @'h200183 {
    field RxEnDlyTg3_u1_p2 @0 {
       bits 11;
       access rw;
       reset 11'h100;
    }
  }
  register RxClkDlyTg0_u1_p2 @'h20018c {
    field RxClkDlyTg0_u1_p2 @0 {
       bits 6;
       access rw;
       reset 6'h10;
    }
  }
  register RxClkDlyTg1_u1_p2 @'h20018d {
    field RxClkDlyTg1_u1_p2 @0 {
       bits 6;
       access rw;
       reset 6'h10;
    }
  }
  register RxClkDlyTg2_u1_p2 @'h20018e {
    field RxClkDlyTg2_u1_p2 @0 {
       bits 6;
       access rw;
       reset 6'h10;
    }
  }
  register RxClkDlyTg3_u1_p2 @'h20018f {
    field RxClkDlyTg3_u1_p2 @0 {
       bits 6;
       access rw;
       reset 6'h10;
    }
  }
  register RxClkcDlyTg0_u1_p2 @'h200190 {
    field RxClkcDlyTg0_u1_p2 @0 {
       bits 6;
       access rw;
       reset 6'h10;
    }
  }
  register RxClkcDlyTg1_u1_p2 @'h200191 {
    field RxClkcDlyTg1_u1_p2 @0 {
       bits 6;
       access rw;
       reset 6'h10;
    }
  }
  register RxClkcDlyTg2_u1_p2 @'h200192 {
    field RxClkcDlyTg2_u1_p2 @0 {
       bits 6;
       access rw;
       reset 6'h10;
    }
  }
  register RxClkcDlyTg3_u1_p2 @'h200193 {
    field RxClkcDlyTg3_u1_p2 @0 {
       bits 6;
       access rw;
       reset 6'h10;
    }
  }
  register TxDqDlyTg0_r1_p2 @'h2001c0 {
    field TxDqDlyTg0_r1_p2 @0 {
       bits 9;
       access rw;
       reset 9'h10;
    }
  }
  register TxDqDlyTg1_r1_p2 @'h2001c1 {
    field TxDqDlyTg1_r1_p2 @0 {
       bits 9;
       access rw;
       reset 9'h10;
    }
  }
  register TxDqDlyTg2_r1_p2 @'h2001c2 {
    field TxDqDlyTg2_r1_p2 @0 {
       bits 9;
       access rw;
       reset 9'h10;
    }
  }
  register TxDqDlyTg3_r1_p2 @'h2001c3 {
    field TxDqDlyTg3_r1_p2 @0 {
       bits 9;
       access rw;
       reset 9'h10;
    }
  }
  register TxDqsDlyTg0_u1_p2 @'h2001d0 {
    field TxDqsDlyTg0_u1_p2 @0 {
       bits 10;
       access rw;
       reset 10'h100;
    }
  }
  register TxDqsDlyTg1_u1_p2 @'h2001d1 {
    field TxDqsDlyTg1_u1_p2 @0 {
       bits 10;
       access rw;
       reset 10'h100;
    }
  }
  register TxDqsDlyTg2_u1_p2 @'h2001d2 {
    field TxDqsDlyTg2_u1_p2 @0 {
       bits 10;
       access rw;
       reset 10'h100;
    }
  }
  register TxDqsDlyTg3_u1_p2 @'h2001d3 {
    field TxDqsDlyTg3_u1_p2 @0 {
       bits 10;
       access rw;
       reset 10'h100;
    }
  }
  register TxDqDlyTg0_r2_p2 @'h2002c0 {
    field TxDqDlyTg0_r2_p2 @0 {
       bits 9;
       access rw;
       reset 9'h10;
    }
  }
  register TxDqDlyTg1_r2_p2 @'h2002c1 {
    field TxDqDlyTg1_r2_p2 @0 {
       bits 9;
       access rw;
       reset 9'h10;
    }
  }
  register TxDqDlyTg2_r2_p2 @'h2002c2 {
    field TxDqDlyTg2_r2_p2 @0 {
       bits 9;
       access rw;
       reset 9'h10;
    }
  }
  register TxDqDlyTg3_r2_p2 @'h2002c3 {
    field TxDqDlyTg3_r2_p2 @0 {
       bits 9;
       access rw;
       reset 9'h10;
    }
  }
  register TxDqDlyTg0_r3_p2 @'h2003c0 {
    field TxDqDlyTg0_r3_p2 @0 {
       bits 9;
       access rw;
       reset 9'h10;
    }
  }
  register TxDqDlyTg1_r3_p2 @'h2003c1 {
    field TxDqDlyTg1_r3_p2 @0 {
       bits 9;
       access rw;
       reset 9'h10;
    }
  }
  register TxDqDlyTg2_r3_p2 @'h2003c2 {
    field TxDqDlyTg2_r3_p2 @0 {
       bits 9;
       access rw;
       reset 9'h10;
    }
  }
  register TxDqDlyTg3_r3_p2 @'h2003c3 {
    field TxDqDlyTg3_r3_p2 @0 {
       bits 9;
       access rw;
       reset 9'h10;
    }
  }
  register TxDqDlyTg0_r4_p2 @'h2004c0 {
    field TxDqDlyTg0_r4_p2 @0 {
       bits 9;
       access rw;
       reset 9'h10;
    }
  }
  register TxDqDlyTg1_r4_p2 @'h2004c1 {
    field TxDqDlyTg1_r4_p2 @0 {
       bits 9;
       access rw;
       reset 9'h10;
    }
  }
  register TxDqDlyTg2_r4_p2 @'h2004c2 {
    field TxDqDlyTg2_r4_p2 @0 {
       bits 9;
       access rw;
       reset 9'h10;
    }
  }
  register TxDqDlyTg3_r4_p2 @'h2004c3 {
    field TxDqDlyTg3_r4_p2 @0 {
       bits 9;
       access rw;
       reset 9'h10;
    }
  }
  register TxDqDlyTg0_r5_p2 @'h2005c0 {
    field TxDqDlyTg0_r5_p2 @0 {
       bits 9;
       access rw;
       reset 9'h10;
    }
  }
  register TxDqDlyTg1_r5_p2 @'h2005c1 {
    field TxDqDlyTg1_r5_p2 @0 {
       bits 9;
       access rw;
       reset 9'h10;
    }
  }
  register TxDqDlyTg2_r5_p2 @'h2005c2 {
    field TxDqDlyTg2_r5_p2 @0 {
       bits 9;
       access rw;
       reset 9'h10;
    }
  }
  register TxDqDlyTg3_r5_p2 @'h2005c3 {
    field TxDqDlyTg3_r5_p2 @0 {
       bits 9;
       access rw;
       reset 9'h10;
    }
  }
  register TxDqDlyTg0_r6_p2 @'h2006c0 {
    field TxDqDlyTg0_r6_p2 @0 {
       bits 9;
       access rw;
       reset 9'h10;
    }
  }
  register TxDqDlyTg1_r6_p2 @'h2006c1 {
    field TxDqDlyTg1_r6_p2 @0 {
       bits 9;
       access rw;
       reset 9'h10;
    }
  }
  register TxDqDlyTg2_r6_p2 @'h2006c2 {
    field TxDqDlyTg2_r6_p2 @0 {
       bits 9;
       access rw;
       reset 9'h10;
    }
  }
  register TxDqDlyTg3_r6_p2 @'h2006c3 {
    field TxDqDlyTg3_r6_p2 @0 {
       bits 9;
       access rw;
       reset 9'h10;
    }
  }
  register TxDqDlyTg0_r7_p2 @'h2007c0 {
    field TxDqDlyTg0_r7_p2 @0 {
       bits 9;
       access rw;
       reset 9'h10;
    }
  }
  register TxDqDlyTg1_r7_p2 @'h2007c1 {
    field TxDqDlyTg1_r7_p2 @0 {
       bits 9;
       access rw;
       reset 9'h10;
    }
  }
  register TxDqDlyTg2_r7_p2 @'h2007c2 {
    field TxDqDlyTg2_r7_p2 @0 {
       bits 9;
       access rw;
       reset 9'h10;
    }
  }
  register TxDqDlyTg3_r7_p2 @'h2007c3 {
    field TxDqDlyTg3_r7_p2 @0 {
       bits 9;
       access rw;
       reset 9'h10;
    }
  }
  register TxDqDlyTg0_r8_p2 @'h2008c0 {
    field TxDqDlyTg0_r8_p2 @0 {
       bits 9;
       access rw;
       reset 9'h10;
    }
  }
  register TxDqDlyTg1_r8_p2 @'h2008c1 {
    field TxDqDlyTg1_r8_p2 @0 {
       bits 9;
       access rw;
       reset 9'h10;
    }
  }
  register TxDqDlyTg2_r8_p2 @'h2008c2 {
    field TxDqDlyTg2_r8_p2 @0 {
       bits 9;
       access rw;
       reset 9'h10;
    }
  }
  register TxDqDlyTg3_r8_p2 @'h2008c3 {
    field TxDqDlyTg3_r8_p2 @0 {
       bits 9;
       access rw;
       reset 9'h10;
    }
  }
  register UseDqsEnReplica_p3 @'h300003 {
    field UseDqsEnReplica_p3 @0 {
       bits 1;
       access rw;
       reset 1'h0;
    }
  }
  register DFIMRL_p3 @'h300020 {
    field DFIMRL_p3 @0 {
       bits 5;
       access rw;
       reset 5'h6;
    }
  }
  register TxImpedanceCtrl0_b0_p3 @'h300041 {
    field DrvStrenDqP @0 {
       bits 6;
       access rw;
       reset 6'h3f;
    }
    field DrvStrenDqN @6 {
       bits 6;
       access rw;
       reset 6'h3f;
    }
  }
  register DqDqsRcvCntrl_b0_p3 @'h300043 {
    field SelAnalogVref @0 {
       bits 1;
       access rw;
       reset 1'h0;
    }
    field ExtVrefRange @1 {
       bits 1;
       access rw;
       reset 1'h0;
    }
    field DfeCtrl @2 {
       bits 2;
       access rw;
       reset 2'h0;
    }
    field MajorModeDbyte @4 {
       bits 3;
       access rw;
       reset 3'h3;
    }
    field GainCurrAdj @7 {
       bits 5;
       access rw;
       reset 5'hb;
    }
    field Reserved @12 {
       bits 4;
    }
  }
  register TxEqualizationMode_p3 @'h300048 {
    field TxEqMode @0 {
       bits 2;
       access rw;
       reset 2'h0;
    }
  }
  register TxImpedanceCtrl1_b0_p3 @'h300049 {
    field DrvStrenFSDqP @0 {
       bits 6;
       access rw;
       reset 6'h3f;
    }
    field DrvStrenFSDqN @6 {
       bits 6;
       access rw;
       reset 6'h3f;
    }
  }
  register TxImpedanceCtrl2_b0_p3 @'h30004b {
    field DrvStrenEQHiDqP @0 {
       bits 6;
       access rw;
       reset 6'h0;
    }
    field DrvStrenEQLoDqN @6 {
       bits 6;
       access rw;
       reset 6'h0;
    }
  }
  register DqDqsRcvCntrl2_p3 @'h30004c {
    field EnRxAgressivePDR @0 {
       bits 1;
       access rw;
       reset 1'h0;
    }
  }
  register TxOdtDrvStren_b0_p3 @'h30004d {
    field ODTStrenP @0 {
       bits 6;
       access rw;
       reset 6'h0;
    }
    field ODTStrenN @6 {
       bits 6;
       access rw;
       reset 6'h0;
    }
  }
  register TxSlewRate_b0_p3 @'h30005f {
    field TxPreP @0 {
       bits 4;
       access rw;
       reset 4'hf;
    }
    field TxPreN @4 {
       bits 4;
       access rw;
       reset 4'hf;
    }
    field TxPreDrvMode @8 {
       bits 3;
       access rw;
       reset 3'h7;
    }
  }
  register RxEnDlyTg0_u0_p3 @'h300080 {
    field RxEnDlyTg0_u0_p3 @0 {
       bits 11;
       access rw;
       reset 11'h100;
    }
  }
  register RxEnDlyTg1_u0_p3 @'h300081 {
    field RxEnDlyTg1_u0_p3 @0 {
       bits 11;
       access rw;
       reset 11'h100;
    }
  }
  register RxEnDlyTg2_u0_p3 @'h300082 {
    field RxEnDlyTg2_u0_p3 @0 {
       bits 11;
       access rw;
       reset 11'h100;
    }
  }
  register RxEnDlyTg3_u0_p3 @'h300083 {
    field RxEnDlyTg3_u0_p3 @0 {
       bits 11;
       access rw;
       reset 11'h100;
    }
  }
  register RxClkDlyTg0_u0_p3 @'h30008c {
    field RxClkDlyTg0_u0_p3 @0 {
       bits 6;
       access rw;
       reset 6'h10;
    }
  }
  register RxClkDlyTg1_u0_p3 @'h30008d {
    field RxClkDlyTg1_u0_p3 @0 {
       bits 6;
       access rw;
       reset 6'h10;
    }
  }
  register RxClkDlyTg2_u0_p3 @'h30008e {
    field RxClkDlyTg2_u0_p3 @0 {
       bits 6;
       access rw;
       reset 6'h10;
    }
  }
  register RxClkDlyTg3_u0_p3 @'h30008f {
    field RxClkDlyTg3_u0_p3 @0 {
       bits 6;
       access rw;
       reset 6'h10;
    }
  }
  register RxClkcDlyTg0_u0_p3 @'h300090 {
    field RxClkcDlyTg0_u0_p3 @0 {
       bits 6;
       access rw;
       reset 6'h10;
    }
  }
  register RxClkcDlyTg1_u0_p3 @'h300091 {
    field RxClkcDlyTg1_u0_p3 @0 {
       bits 6;
       access rw;
       reset 6'h10;
    }
  }
  register RxClkcDlyTg2_u0_p3 @'h300092 {
    field RxClkcDlyTg2_u0_p3 @0 {
       bits 6;
       access rw;
       reset 6'h10;
    }
  }
  register RxClkcDlyTg3_u0_p3 @'h300093 {
    field RxClkcDlyTg3_u0_p3 @0 {
       bits 6;
       access rw;
       reset 6'h10;
    }
  }
  register PptDqsCntInvTrnTg0_p3 @'h3000ae {
    field PptDqsCntInvTrnTg0_p3 @0 {
       bits 16;
       access rw;
       reset 16'h0;
    }
  }
  register PptDqsCntInvTrnTg1_p3 @'h3000af {
    field PptDqsCntInvTrnTg1_p3 @0 {
       bits 16;
       access rw;
       reset 16'h0;
    }
  }
  register TxDqDlyTg0_r0_p3 @'h3000c0 {
    field TxDqDlyTg0_r0_p3 @0 {
       bits 9;
       access rw;
       reset 9'h10;
    }
  }
  register TxDqDlyTg1_r0_p3 @'h3000c1 {
    field TxDqDlyTg1_r0_p3 @0 {
       bits 9;
       access rw;
       reset 9'h10;
    }
  }
  register TxDqDlyTg2_r0_p3 @'h3000c2 {
    field TxDqDlyTg2_r0_p3 @0 {
       bits 9;
       access rw;
       reset 9'h10;
    }
  }
  register TxDqDlyTg3_r0_p3 @'h3000c3 {
    field TxDqDlyTg3_r0_p3 @0 {
       bits 9;
       access rw;
       reset 9'h10;
    }
  }
  register TxDqsDlyTg0_u0_p3 @'h3000d0 {
    field TxDqsDlyTg0_u0_p3 @0 {
       bits 10;
       access rw;
       reset 10'h100;
    }
  }
  register TxDqsDlyTg1_u0_p3 @'h3000d1 {
    field TxDqsDlyTg1_u0_p3 @0 {
       bits 10;
       access rw;
       reset 10'h100;
    }
  }
  register TxDqsDlyTg2_u0_p3 @'h3000d2 {
    field TxDqsDlyTg2_u0_p3 @0 {
       bits 10;
       access rw;
       reset 10'h100;
    }
  }
  register TxDqsDlyTg3_u0_p3 @'h3000d3 {
    field TxDqsDlyTg3_u0_p3 @0 {
       bits 10;
       access rw;
       reset 10'h100;
    }
  }
  register TxImpedanceCtrl0_b1_p3 @'h300141 {
    field DrvStrenDqP @0 {
       bits 6;
       access rw;
       reset 6'h3f;
    }
    field DrvStrenDqN @6 {
       bits 6;
       access rw;
       reset 6'h3f;
    }
  }
  register DqDqsRcvCntrl_b1_p3 @'h300143 {
    field SelAnalogVref @0 {
       bits 1;
       access rw;
       reset 1'h0;
    }
    field ExtVrefRange @1 {
       bits 1;
       access rw;
       reset 1'h0;
    }
    field DfeCtrl @2 {
       bits 2;
       access rw;
       reset 2'h0;
    }
    field MajorModeDbyte @4 {
       bits 3;
       access rw;
       reset 3'h3;
    }
    field GainCurrAdj @7 {
       bits 5;
       access rw;
       reset 5'hb;
    }
    field Reserved @12 {
       bits 4;
    }
  }
  register TxImpedanceCtrl1_b1_p3 @'h300149 {
    field DrvStrenFSDqP @0 {
       bits 6;
       access rw;
       reset 6'h3f;
    }
    field DrvStrenFSDqN @6 {
       bits 6;
       access rw;
       reset 6'h3f;
    }
  }
  register TxImpedanceCtrl2_b1_p3 @'h30014b {
    field DrvStrenEQHiDqP @0 {
       bits 6;
       access rw;
       reset 6'h0;
    }
    field DrvStrenEQLoDqN @6 {
       bits 6;
       access rw;
       reset 6'h0;
    }
  }
  register TxOdtDrvStren_b1_p3 @'h30014d {
    field ODTStrenP @0 {
       bits 6;
       access rw;
       reset 6'h0;
    }
    field ODTStrenN @6 {
       bits 6;
       access rw;
       reset 6'h0;
    }
  }
  register TxSlewRate_b1_p3 @'h30015f {
    field TxPreP @0 {
       bits 4;
       access rw;
       reset 4'hf;
    }
    field TxPreN @4 {
       bits 4;
       access rw;
       reset 4'hf;
    }
    field TxPreDrvMode @8 {
       bits 3;
       access rw;
       reset 3'h7;
    }
  }
  register RxEnDlyTg0_u1_p3 @'h300180 {
    field RxEnDlyTg0_u1_p3 @0 {
       bits 11;
       access rw;
       reset 11'h100;
    }
  }
  register RxEnDlyTg1_u1_p3 @'h300181 {
    field RxEnDlyTg1_u1_p3 @0 {
       bits 11;
       access rw;
       reset 11'h100;
    }
  }
  register RxEnDlyTg2_u1_p3 @'h300182 {
    field RxEnDlyTg2_u1_p3 @0 {
       bits 11;
       access rw;
       reset 11'h100;
    }
  }
  register RxEnDlyTg3_u1_p3 @'h300183 {
    field RxEnDlyTg3_u1_p3 @0 {
       bits 11;
       access rw;
       reset 11'h100;
    }
  }
  register RxClkDlyTg0_u1_p3 @'h30018c {
    field RxClkDlyTg0_u1_p3 @0 {
       bits 6;
       access rw;
       reset 6'h10;
    }
  }
  register RxClkDlyTg1_u1_p3 @'h30018d {
    field RxClkDlyTg1_u1_p3 @0 {
       bits 6;
       access rw;
       reset 6'h10;
    }
  }
  register RxClkDlyTg2_u1_p3 @'h30018e {
    field RxClkDlyTg2_u1_p3 @0 {
       bits 6;
       access rw;
       reset 6'h10;
    }
  }
  register RxClkDlyTg3_u1_p3 @'h30018f {
    field RxClkDlyTg3_u1_p3 @0 {
       bits 6;
       access rw;
       reset 6'h10;
    }
  }
  register RxClkcDlyTg0_u1_p3 @'h300190 {
    field RxClkcDlyTg0_u1_p3 @0 {
       bits 6;
       access rw;
       reset 6'h10;
    }
  }
  register RxClkcDlyTg1_u1_p3 @'h300191 {
    field RxClkcDlyTg1_u1_p3 @0 {
       bits 6;
       access rw;
       reset 6'h10;
    }
  }
  register RxClkcDlyTg2_u1_p3 @'h300192 {
    field RxClkcDlyTg2_u1_p3 @0 {
       bits 6;
       access rw;
       reset 6'h10;
    }
  }
  register RxClkcDlyTg3_u1_p3 @'h300193 {
    field RxClkcDlyTg3_u1_p3 @0 {
       bits 6;
       access rw;
       reset 6'h10;
    }
  }
  register TxDqDlyTg0_r1_p3 @'h3001c0 {
    field TxDqDlyTg0_r1_p3 @0 {
       bits 9;
       access rw;
       reset 9'h10;
    }
  }
  register TxDqDlyTg1_r1_p3 @'h3001c1 {
    field TxDqDlyTg1_r1_p3 @0 {
       bits 9;
       access rw;
       reset 9'h10;
    }
  }
  register TxDqDlyTg2_r1_p3 @'h3001c2 {
    field TxDqDlyTg2_r1_p3 @0 {
       bits 9;
       access rw;
       reset 9'h10;
    }
  }
  register TxDqDlyTg3_r1_p3 @'h3001c3 {
    field TxDqDlyTg3_r1_p3 @0 {
       bits 9;
       access rw;
       reset 9'h10;
    }
  }
  register TxDqsDlyTg0_u1_p3 @'h3001d0 {
    field TxDqsDlyTg0_u1_p3 @0 {
       bits 10;
       access rw;
       reset 10'h100;
    }
  }
  register TxDqsDlyTg1_u1_p3 @'h3001d1 {
    field TxDqsDlyTg1_u1_p3 @0 {
       bits 10;
       access rw;
       reset 10'h100;
    }
  }
  register TxDqsDlyTg2_u1_p3 @'h3001d2 {
    field TxDqsDlyTg2_u1_p3 @0 {
       bits 10;
       access rw;
       reset 10'h100;
    }
  }
  register TxDqsDlyTg3_u1_p3 @'h3001d3 {
    field TxDqsDlyTg3_u1_p3 @0 {
       bits 10;
       access rw;
       reset 10'h100;
    }
  }
  register TxDqDlyTg0_r2_p3 @'h3002c0 {
    field TxDqDlyTg0_r2_p3 @0 {
       bits 9;
       access rw;
       reset 9'h10;
    }
  }
  register TxDqDlyTg1_r2_p3 @'h3002c1 {
    field TxDqDlyTg1_r2_p3 @0 {
       bits 9;
       access rw;
       reset 9'h10;
    }
  }
  register TxDqDlyTg2_r2_p3 @'h3002c2 {
    field TxDqDlyTg2_r2_p3 @0 {
       bits 9;
       access rw;
       reset 9'h10;
    }
  }
  register TxDqDlyTg3_r2_p3 @'h3002c3 {
    field TxDqDlyTg3_r2_p3 @0 {
       bits 9;
       access rw;
       reset 9'h10;
    }
  }
  register TxDqDlyTg0_r3_p3 @'h3003c0 {
    field TxDqDlyTg0_r3_p3 @0 {
       bits 9;
       access rw;
       reset 9'h10;
    }
  }
  register TxDqDlyTg1_r3_p3 @'h3003c1 {
    field TxDqDlyTg1_r3_p3 @0 {
       bits 9;
       access rw;
       reset 9'h10;
    }
  }
  register TxDqDlyTg2_r3_p3 @'h3003c2 {
    field TxDqDlyTg2_r3_p3 @0 {
       bits 9;
       access rw;
       reset 9'h10;
    }
  }
  register TxDqDlyTg3_r3_p3 @'h3003c3 {
    field TxDqDlyTg3_r3_p3 @0 {
       bits 9;
       access rw;
       reset 9'h10;
    }
  }
  register TxDqDlyTg0_r4_p3 @'h3004c0 {
    field TxDqDlyTg0_r4_p3 @0 {
       bits 9;
       access rw;
       reset 9'h10;
    }
  }
  register TxDqDlyTg1_r4_p3 @'h3004c1 {
    field TxDqDlyTg1_r4_p3 @0 {
       bits 9;
       access rw;
       reset 9'h10;
    }
  }
  register TxDqDlyTg2_r4_p3 @'h3004c2 {
    field TxDqDlyTg2_r4_p3 @0 {
       bits 9;
       access rw;
       reset 9'h10;
    }
  }
  register TxDqDlyTg3_r4_p3 @'h3004c3 {
    field TxDqDlyTg3_r4_p3 @0 {
       bits 9;
       access rw;
       reset 9'h10;
    }
  }
  register TxDqDlyTg0_r5_p3 @'h3005c0 {
    field TxDqDlyTg0_r5_p3 @0 {
       bits 9;
       access rw;
       reset 9'h10;
    }
  }
  register TxDqDlyTg1_r5_p3 @'h3005c1 {
    field TxDqDlyTg1_r5_p3 @0 {
       bits 9;
       access rw;
       reset 9'h10;
    }
  }
  register TxDqDlyTg2_r5_p3 @'h3005c2 {
    field TxDqDlyTg2_r5_p3 @0 {
       bits 9;
       access rw;
       reset 9'h10;
    }
  }
  register TxDqDlyTg3_r5_p3 @'h3005c3 {
    field TxDqDlyTg3_r5_p3 @0 {
       bits 9;
       access rw;
       reset 9'h10;
    }
  }
  register TxDqDlyTg0_r6_p3 @'h3006c0 {
    field TxDqDlyTg0_r6_p3 @0 {
       bits 9;
       access rw;
       reset 9'h10;
    }
  }
  register TxDqDlyTg1_r6_p3 @'h3006c1 {
    field TxDqDlyTg1_r6_p3 @0 {
       bits 9;
       access rw;
       reset 9'h10;
    }
  }
  register TxDqDlyTg2_r6_p3 @'h3006c2 {
    field TxDqDlyTg2_r6_p3 @0 {
       bits 9;
       access rw;
       reset 9'h10;
    }
  }
  register TxDqDlyTg3_r6_p3 @'h3006c3 {
    field TxDqDlyTg3_r6_p3 @0 {
       bits 9;
       access rw;
       reset 9'h10;
    }
  }
  register TxDqDlyTg0_r7_p3 @'h3007c0 {
    field TxDqDlyTg0_r7_p3 @0 {
       bits 9;
       access rw;
       reset 9'h10;
    }
  }
  register TxDqDlyTg1_r7_p3 @'h3007c1 {
    field TxDqDlyTg1_r7_p3 @0 {
       bits 9;
       access rw;
       reset 9'h10;
    }
  }
  register TxDqDlyTg2_r7_p3 @'h3007c2 {
    field TxDqDlyTg2_r7_p3 @0 {
       bits 9;
       access rw;
       reset 9'h10;
    }
  }
  register TxDqDlyTg3_r7_p3 @'h3007c3 {
    field TxDqDlyTg3_r7_p3 @0 {
       bits 9;
       access rw;
       reset 9'h10;
    }
  }
  register TxDqDlyTg0_r8_p3 @'h3008c0 {
    field TxDqDlyTg0_r8_p3 @0 {
       bits 9;
       access rw;
       reset 9'h10;
    }
  }
  register TxDqDlyTg1_r8_p3 @'h3008c1 {
    field TxDqDlyTg1_r8_p3 @0 {
       bits 9;
       access rw;
       reset 9'h10;
    }
  }
  register TxDqDlyTg2_r8_p3 @'h3008c2 {
    field TxDqDlyTg2_r8_p3 @0 {
       bits 9;
       access rw;
       reset 9'h10;
    }
  }
  register TxDqDlyTg3_r8_p3 @'h3008c3 {
    field TxDqDlyTg3_r8_p3 @0 {
       bits 9;
       access rw;
       reset 9'h10;
    }
  }
}
block dwc_ddrphy_top_DWC_DDRPHYA_DBYTE2 {
  endian little;
  bytes 2;
  register DbyteMiscMode @'h0 {
    field Reserved @0 {
       bits 2;
    }
    field DByteDisable @2 {
       bits 1;
       access rw;
       reset 1'h0;
    }
  }
  register TsmByte0 @'h1 {
    field RFU_TsmByte0 @0 {
       bits 16;
       access rw;
       reset 16'h0;
    }
  }
  register TrainingParam @'h2 {
    field RFU_TrainingParam @0 {
       bits 16;
       access rw;
       reset 16'h0;
    }
  }
  register UseDqsEnReplica_p0 @'h3 {
    field UseDqsEnReplica_p0 @0 {
       bits 1;
       access rw;
       reset 1'h0;
    }
  }
  register RxTrainPatternEnable @'h10 {
    field RxTrainPatternEnable @0 {
       bits 1;
       access rw;
       reset 1'h0;
    }
  }
  register TsmByte1 @'h11 {
    field RFU_TsmByte1 @0 {
       bits 16;
       access rw;
       reset 16'h0;
    }
  }
  register TsmByte2 @'h12 {
    field RFU_TsmByte2 @0 {
       bits 16;
       access rw;
       reset 16'h0;
    }
  }
  register TsmByte3 @'h13 {
    field RFU_TsmByte3 @0 {
       bits 9;
       access rw;
       reset 9'h0;
    }
  }
  register TsmByte4 @'h14 {
    field RFU_TsmByte4 @0 {
       bits 4;
       access rw;
       reset 4'h0;
    }
  }
  register TestModeConfig @'h17 {
    field RFU_TestModeConfig @0 {
       bits 10;
       access rw;
       reset 10'h0;
    }
  }
  register TsmByte5 @'h18 {
    field RFU_TsmByte5 @0 {
       bits 16;
       access rw;
       reset 16'h0;
    }
  }
  register MtestMuxSel @'h1a {
    field MtestMuxSel @0 {
       bits 6;
       access rw;
       reset 6'h0;
    }
  }
  register DtsmTrainModeCtrl @'h1f {
    field RFU_DtsmTrainModeCtrl @0 {
       bits 4;
       access rw;
       reset 4'h0;
    }
  }
  register DFIMRL_p0 @'h20 {
    field DFIMRL_p0 @0 {
       bits 5;
       access rw;
       reset 5'h6;
    }
  }
  register AsyncDbyteMode @'h24 {
    field AsyncDbyteMode @0 {
       bits 9;
       access rw;
       reset 9'h0;
    }
  }
  register AsyncDbyteTxEn @'h26 {
    field AsyncDbyteTxEn @0 {
       bits 12;
       access rw;
       reset 12'h0;
    }
  }
  register AsyncDbyteTxData @'h28 {
    field AsyncDbyteTxData @0 {
       bits 12;
       access rw;
       reset 12'h0;
    }
  }
  register AsyncDbyteRxData @'h2a {
    field AsyncDbyteRxData @0 {
       bits 12;
       access ro;
       reset 12'h0;
    }
  }
  register VrefDAC1_r0 @'h30 {
    field VrefDAC1_r0 @0 {
       bits 7;
       access rw;
       reset 7'h0;
    }
  }
  register TrainingCntr_r0 @'h32 {
    field RFU_TrainingCntr_r0 @0 {
       bits 16;
       access rw;
       reset 16'h0;
    }
  }
  register VrefDAC0_r0 @'h40 {
    field VrefDAC0_r0 @0 {
       bits 7;
       access rw;
       reset 7'h0;
    }
  }
  register TxImpedanceCtrl0_b0_p0 @'h41 {
    field DrvStrenDqP @0 {
       bits 6;
       access rw;
       reset 6'h3f;
    }
    field DrvStrenDqN @6 {
       bits 6;
       access rw;
       reset 6'h3f;
    }
  }
  register DqDqsRcvCntrl_b0_p0 @'h43 {
    field SelAnalogVref @0 {
       bits 1;
       access rw;
       reset 1'h0;
    }
    field ExtVrefRange @1 {
       bits 1;
       access rw;
       reset 1'h0;
    }
    field DfeCtrl @2 {
       bits 2;
       access rw;
       reset 2'h0;
    }
    field MajorModeDbyte @4 {
       bits 3;
       access rw;
       reset 3'h3;
    }
    field GainCurrAdj @7 {
       bits 5;
       access rw;
       reset 5'hb;
    }
    field Reserved @12 {
       bits 4;
    }
  }
  register TxEqualizationMode_p0 @'h48 {
    field TxEqMode @0 {
       bits 2;
       access rw;
       reset 2'h0;
    }
  }
  register TxImpedanceCtrl1_b0_p0 @'h49 {
    field DrvStrenFSDqP @0 {
       bits 6;
       access rw;
       reset 6'h3f;
    }
    field DrvStrenFSDqN @6 {
       bits 6;
       access rw;
       reset 6'h3f;
    }
  }
  register DqDqsRcvCntrl1 @'h4a {
    field PowerDownRcvr @0 {
       bits 9;
       access rw;
       reset 9'h0;
    }
    field PowerDownRcvrDqs @9 {
       bits 1;
       access rw;
       reset 1'h0;
    }
    field RxPadStandbyEn @10 {
       bits 1;
       access rw;
       reset 1'h1;
    }
    field EnLPReqPDR @11 {
       bits 1;
       access rw;
       reset 1'h0;
    }
  }
  register TxImpedanceCtrl2_b0_p0 @'h4b {
    field DrvStrenEQHiDqP @0 {
       bits 6;
       access rw;
       reset 6'h0;
    }
    field DrvStrenEQLoDqN @6 {
       bits 6;
       access rw;
       reset 6'h0;
    }
  }
  register DqDqsRcvCntrl2_p0 @'h4c {
    field EnRxAgressivePDR @0 {
       bits 1;
       access rw;
       reset 1'h0;
    }
  }
  register TxOdtDrvStren_b0_p0 @'h4d {
    field ODTStrenP @0 {
       bits 6;
       access rw;
       reset 6'h0;
    }
    field ODTStrenN @6 {
       bits 6;
       access rw;
       reset 6'h0;
    }
  }
  register RxFifoCheckStatus @'h56 {
    field RxFifoLocErr @0 {
       bits 1;
       access ro;
       reset 1'h0;
    }
    field RxFifoLocUErr @1 {
       bits 1;
       access ro;
       reset 1'h0;
    }
  }
  register RxFifoCheckErrValues @'h57 {
    field RxFifoRdLocErrValue @0 {
       bits 4;
       access ro;
       reset 4'h0;
    }
    field RxFifoWrLocErrValue @4 {
       bits 4;
       access ro;
       reset 4'h0;
    }
    field RxFifoRdLocUErrValue @8 {
       bits 4;
       access ro;
       reset 4'h0;
    }
    field RxFifoWrLocUErrValue @12 {
       bits 4;
       access ro;
       reset 4'h0;
    }
  }
  register RxFifoInfo @'h58 {
    field RxFifoRdLoc @0 {
       bits 4;
       access ro;
       reset 4'h0;
    }
    field RxFifoWrLoc @4 {
       bits 4;
       access ro;
       reset 4'h0;
    }
    field RxFifoRdLocU @8 {
       bits 4;
       access ro;
       reset 4'h0;
    }
    field RxFifoWrLocU @12 {
       bits 4;
       access ro;
       reset 4'h0;
    }
  }
  register RxFifoVisibility @'h59 {
    field RxFifoRdPtr @0 {
       bits 3;
       access rw;
       reset 3'h0;
    }
    field RxFifoRdPtrOvr @3 {
       bits 1;
       access rw;
       reset 1'h0;
    }
    field RxFifoRdEn @4 {
       bits 1;
       access rw;
       reset 1'h0;
    }
  }
  register RxFifoContentsDQ3210 @'h5a {
    field RxFifoContentsDQ3210 @0 {
       bits 16;
       access ro;
       reset 16'h0;
    }
  }
  register RxFifoContentsDQ7654 @'h5b {
    field RxFifoContentsDQ7654 @0 {
       bits 16;
       access ro;
       reset 16'h0;
    }
  }
  register RxFifoContentsDBI @'h5c {
    field RxFifoContentsDBI @0 {
       bits 4;
       access ro;
       reset 4'h0;
    }
  }
  register TxSlewRate_b0_p0 @'h5f {
    field TxPreP @0 {
       bits 4;
       access rw;
       reset 4'hf;
    }
    field TxPreN @4 {
       bits 4;
       access rw;
       reset 4'hf;
    }
    field TxPreDrvMode @8 {
       bits 3;
       access rw;
       reset 3'h7;
    }
  }
  register TrainingIncDecDtsmEn_r0 @'h62 {
    field TrainingIncDecDtsmEn_r0 @0 {
       bits 9;
       access rw;
       reset 9'h0;
    }
  }
  register RxPBDlyTg0_r0 @'h68 {
    field RxPBDlyTg0_r0 @0 {
       bits 7;
       access rw;
       reset 7'h0;
    }
  }
  register RxPBDlyTg1_r0 @'h69 {
    field RxPBDlyTg1_r0 @0 {
       bits 7;
       access rw;
       reset 7'h0;
    }
  }
  register RxPBDlyTg2_r0 @'h6a {
    field RxPBDlyTg2_r0 @0 {
       bits 7;
       access rw;
       reset 7'h0;
    }
  }
  register RxPBDlyTg3_r0 @'h6b {
    field RxPBDlyTg3_r0 @0 {
       bits 7;
       access rw;
       reset 7'h0;
    }
  }
  register RxEnDlyTg0_u0_p0 @'h80 {
    field RxEnDlyTg0_u0_p0 @0 {
       bits 11;
       access rw;
       reset 11'h100;
    }
  }
  register RxEnDlyTg1_u0_p0 @'h81 {
    field RxEnDlyTg1_u0_p0 @0 {
       bits 11;
       access rw;
       reset 11'h100;
    }
  }
  register RxEnDlyTg2_u0_p0 @'h82 {
    field RxEnDlyTg2_u0_p0 @0 {
       bits 11;
       access rw;
       reset 11'h100;
    }
  }
  register RxEnDlyTg3_u0_p0 @'h83 {
    field RxEnDlyTg3_u0_p0 @0 {
       bits 11;
       access rw;
       reset 11'h100;
    }
  }
  register RxClkDlyTg0_u0_p0 @'h8c {
    field RxClkDlyTg0_u0_p0 @0 {
       bits 6;
       access rw;
       reset 6'h10;
    }
  }
  register RxClkDlyTg1_u0_p0 @'h8d {
    field RxClkDlyTg1_u0_p0 @0 {
       bits 6;
       access rw;
       reset 6'h10;
    }
  }
  register RxClkDlyTg2_u0_p0 @'h8e {
    field RxClkDlyTg2_u0_p0 @0 {
       bits 6;
       access rw;
       reset 6'h10;
    }
  }
  register RxClkDlyTg3_u0_p0 @'h8f {
    field RxClkDlyTg3_u0_p0 @0 {
       bits 6;
       access rw;
       reset 6'h10;
    }
  }
  register RxClkcDlyTg0_u0_p0 @'h90 {
    field RxClkcDlyTg0_u0_p0 @0 {
       bits 6;
       access rw;
       reset 6'h10;
    }
  }
  register RxClkcDlyTg1_u0_p0 @'h91 {
    field RxClkcDlyTg1_u0_p0 @0 {
       bits 6;
       access rw;
       reset 6'h10;
    }
  }
  register RxClkcDlyTg2_u0_p0 @'h92 {
    field RxClkcDlyTg2_u0_p0 @0 {
       bits 6;
       access rw;
       reset 6'h10;
    }
  }
  register RxClkcDlyTg3_u0_p0 @'h93 {
    field RxClkcDlyTg3_u0_p0 @0 {
       bits 6;
       access rw;
       reset 6'h10;
    }
  }
  register Dq0LnSel @'ha0 {
    field Dq0LnSel @0 {
       bits 3;
       access rw;
       reset 3'h0;
    }
  }
  register Dq1LnSel @'ha1 {
    field Dq1LnSel @0 {
       bits 3;
       access rw;
       reset 3'h1;
    }
  }
  register Dq2LnSel @'ha2 {
    field Dq2LnSel @0 {
       bits 3;
       access rw;
       reset 3'h2;
    }
  }
  register Dq3LnSel @'ha3 {
    field Dq3LnSel @0 {
       bits 3;
       access rw;
       reset 3'h3;
    }
  }
  register Dq4LnSel @'ha4 {
    field Dq4LnSel @0 {
       bits 3;
       access rw;
       reset 3'h4;
    }
  }
  register Dq5LnSel @'ha5 {
    field Dq5LnSel @0 {
       bits 3;
       access rw;
       reset 3'h5;
    }
  }
  register Dq6LnSel @'ha6 {
    field Dq6LnSel @0 {
       bits 3;
       access rw;
       reset 3'h6;
    }
  }
  register Dq7LnSel @'ha7 {
    field Dq7LnSel @0 {
       bits 3;
       access rw;
       reset 3'h7;
    }
  }
  register PptCtlStatic @'haa {
    field RFU_PptCtlStatic @0 {
       bits 12;
       access rw;
       reset 12'h0;
    }
  }
  register PptCtlDyn @'hab {
    field RFU_PptCtlDyn @0 {
       bits 2;
       access rw;
       reset 2'h0;
    }
  }
  register PptInfo @'hac {
    field PptInfo @0 {
       bits 16;
       access ro;
       reset 16'h0;
    }
  }
  register PptRxEnEvnt @'had {
    field RFU_PptRxEnEvnt @0 {
       bits 2;
       access rw;
       reset 2'h0;
    }
  }
  register PptDqsCntInvTrnTg0_p0 @'hae {
    field PptDqsCntInvTrnTg0_p0 @0 {
       bits 16;
       access rw;
       reset 16'h0;
    }
  }
  register PptDqsCntInvTrnTg1_p0 @'haf {
    field PptDqsCntInvTrnTg1_p0 @0 {
       bits 16;
       access rw;
       reset 16'h0;
    }
  }
  register DtsmBlankingCtrl @'hb1 {
    field RFU_DtsmBlankingCtrl @0 {
       bits 10;
       access rw;
       reset 10'h0;
    }
  }
  register Tsm0_i0 @'hb2 {
    field RFU_Tsm0_i0 @0 {
       bits 14;
       access rw;
       reset 14'h0;
    }
  }
  register Tsm1_i0 @'hb3 {
    field RFU_Tsm1_i0 @0 {
       bits 16;
       access ro;
       reset 16'h0;
    }
  }
  register Tsm2_i0 @'hb4 {
    field RFU_Tsm2_i0 @0 {
       bits 1;
       access rw;
       reset 1'h0;
    }
  }
  register Tsm3 @'hb5 {
    field RFU_Tsm3 @0 {
       bits 10;
       access rw;
       reset 10'h0;
    }
  }
  register TxChkDataSelects @'hb6 {
    field RFU_TxChkDataSelects @0 {
       bits 2;
       access rw;
       reset 2'h0;
    }
  }
  register DtsmUpThldXingInd @'hb7 {
    field DtsmUpThldXingInd @0 {
       bits 9;
       access ro;
       reset 9'h0;
    }
  }
  register DtsmLoThldXingInd @'hb8 {
    field DtsmLoThldXingInd @0 {
       bits 9;
       access ro;
       reset 9'h0;
    }
  }
  register DbyteAllDtsmCtrl0 @'hb9 {
    field RFU_DbyteAllDtsmCtrl0 @0 {
       bits 9;
       access rw;
       reset 9'h0;
    }
  }
  register DbyteAllDtsmCtrl1 @'hba {
    field RFU_DbyteAllDtsmCtrl1 @0 {
       bits 9;
       access rw;
       reset 9'h0;
    }
  }
  register DbyteAllDtsmCtrl2 @'hbb {
    field RFU_DbyteAllDtsmCtrl2 @0 {
       bits 9;
       access rw;
       reset 9'h0;
    }
  }
  register TxDqDlyTg0_r0_p0 @'hc0 {
    field TxDqDlyTg0_r0_p0 @0 {
       bits 9;
       access rw;
       reset 9'h10;
    }
  }
  register TxDqDlyTg1_r0_p0 @'hc1 {
    field TxDqDlyTg1_r0_p0 @0 {
       bits 9;
       access rw;
       reset 9'h10;
    }
  }
  register TxDqDlyTg2_r0_p0 @'hc2 {
    field TxDqDlyTg2_r0_p0 @0 {
       bits 9;
       access rw;
       reset 9'h10;
    }
  }
  register TxDqDlyTg3_r0_p0 @'hc3 {
    field TxDqDlyTg3_r0_p0 @0 {
       bits 9;
       access rw;
       reset 9'h10;
    }
  }
  register TxDqsDlyTg0_u0_p0 @'hd0 {
    field TxDqsDlyTg0_u0_p0 @0 {
       bits 10;
       access rw;
       reset 10'h100;
    }
  }
  register TxDqsDlyTg1_u0_p0 @'hd1 {
    field TxDqsDlyTg1_u0_p0 @0 {
       bits 10;
       access rw;
       reset 10'h100;
    }
  }
  register TxDqsDlyTg2_u0_p0 @'hd2 {
    field TxDqsDlyTg2_u0_p0 @0 {
       bits 10;
       access rw;
       reset 10'h100;
    }
  }
  register TxDqsDlyTg3_u0_p0 @'hd3 {
    field TxDqsDlyTg3_u0_p0 @0 {
       bits 10;
       access rw;
       reset 10'h100;
    }
  }
  register DxLcdlStatus @'he4 {
    field DxLcdlFineSnapVal @0 {
       bits 10;
       access ro;
       reset 10'h0;
    }
    field DxLcdlPhdSnapVal @10 {
       bits 1;
       access ro;
       reset 1'h0;
    }
    field DxLcdlStickyLock @11 {
       bits 1;
       access ro;
       reset 1'h0;
    }
    field DxLcdlStickyUnlock @12 {
       bits 1;
       access ro;
       reset 1'h0;
    }
    field DxLcdlLiveLock @13 {
       bits 1;
       access ro;
       reset 1'h0;
    }
  }
  register VrefDAC1_r1 @'h130 {
    field VrefDAC1_r1 @0 {
       bits 7;
       access rw;
       reset 7'h0;
    }
  }
  register TrainingCntr_r1 @'h132 {
    field RFU_TrainingCntr_r1 @0 {
       bits 16;
       access rw;
       reset 16'h0;
    }
  }
  register VrefDAC0_r1 @'h140 {
    field VrefDAC0_r1 @0 {
       bits 7;
       access rw;
       reset 7'h0;
    }
  }
  register TxImpedanceCtrl0_b1_p0 @'h141 {
    field DrvStrenDqP @0 {
       bits 6;
       access rw;
       reset 6'h3f;
    }
    field DrvStrenDqN @6 {
       bits 6;
       access rw;
       reset 6'h3f;
    }
  }
  register DqDqsRcvCntrl_b1_p0 @'h143 {
    field SelAnalogVref @0 {
       bits 1;
       access rw;
       reset 1'h0;
    }
    field ExtVrefRange @1 {
       bits 1;
       access rw;
       reset 1'h0;
    }
    field DfeCtrl @2 {
       bits 2;
       access rw;
       reset 2'h0;
    }
    field MajorModeDbyte @4 {
       bits 3;
       access rw;
       reset 3'h3;
    }
    field GainCurrAdj @7 {
       bits 5;
       access rw;
       reset 5'hb;
    }
    field Reserved @12 {
       bits 4;
    }
  }
  register TxImpedanceCtrl1_b1_p0 @'h149 {
    field DrvStrenFSDqP @0 {
       bits 6;
       access rw;
       reset 6'h3f;
    }
    field DrvStrenFSDqN @6 {
       bits 6;
       access rw;
       reset 6'h3f;
    }
  }
  register TxImpedanceCtrl2_b1_p0 @'h14b {
    field DrvStrenEQHiDqP @0 {
       bits 6;
       access rw;
       reset 6'h0;
    }
    field DrvStrenEQLoDqN @6 {
       bits 6;
       access rw;
       reset 6'h0;
    }
  }
  register TxOdtDrvStren_b1_p0 @'h14d {
    field ODTStrenP @0 {
       bits 6;
       access rw;
       reset 6'h0;
    }
    field ODTStrenN @6 {
       bits 6;
       access rw;
       reset 6'h0;
    }
  }
  register TxSlewRate_b1_p0 @'h15f {
    field TxPreP @0 {
       bits 4;
       access rw;
       reset 4'hf;
    }
    field TxPreN @4 {
       bits 4;
       access rw;
       reset 4'hf;
    }
    field TxPreDrvMode @8 {
       bits 3;
       access rw;
       reset 3'h7;
    }
  }
  register TrainingIncDecDtsmEn_r1 @'h162 {
    field TrainingIncDecDtsmEn_r1 @0 {
       bits 9;
       access rw;
       reset 9'h0;
    }
  }
  register RxPBDlyTg0_r1 @'h168 {
    field RxPBDlyTg0_r1 @0 {
       bits 7;
       access rw;
       reset 7'h0;
    }
  }
  register RxPBDlyTg1_r1 @'h169 {
    field RxPBDlyTg1_r1 @0 {
       bits 7;
       access rw;
       reset 7'h0;
    }
  }
  register RxPBDlyTg2_r1 @'h16a {
    field RxPBDlyTg2_r1 @0 {
       bits 7;
       access rw;
       reset 7'h0;
    }
  }
  register RxPBDlyTg3_r1 @'h16b {
    field RxPBDlyTg3_r1 @0 {
       bits 7;
       access rw;
       reset 7'h0;
    }
  }
  register RxEnDlyTg0_u1_p0 @'h180 {
    field RxEnDlyTg0_u1_p0 @0 {
       bits 11;
       access rw;
       reset 11'h100;
    }
  }
  register RxEnDlyTg1_u1_p0 @'h181 {
    field RxEnDlyTg1_u1_p0 @0 {
       bits 11;
       access rw;
       reset 11'h100;
    }
  }
  register RxEnDlyTg2_u1_p0 @'h182 {
    field RxEnDlyTg2_u1_p0 @0 {
       bits 11;
       access rw;
       reset 11'h100;
    }
  }
  register RxEnDlyTg3_u1_p0 @'h183 {
    field RxEnDlyTg3_u1_p0 @0 {
       bits 11;
       access rw;
       reset 11'h100;
    }
  }
  register RxClkDlyTg0_u1_p0 @'h18c {
    field RxClkDlyTg0_u1_p0 @0 {
       bits 6;
       access rw;
       reset 6'h10;
    }
  }
  register RxClkDlyTg1_u1_p0 @'h18d {
    field RxClkDlyTg1_u1_p0 @0 {
       bits 6;
       access rw;
       reset 6'h10;
    }
  }
  register RxClkDlyTg2_u1_p0 @'h18e {
    field RxClkDlyTg2_u1_p0 @0 {
       bits 6;
       access rw;
       reset 6'h10;
    }
  }
  register RxClkDlyTg3_u1_p0 @'h18f {
    field RxClkDlyTg3_u1_p0 @0 {
       bits 6;
       access rw;
       reset 6'h10;
    }
  }
  register RxClkcDlyTg0_u1_p0 @'h190 {
    field RxClkcDlyTg0_u1_p0 @0 {
       bits 6;
       access rw;
       reset 6'h10;
    }
  }
  register RxClkcDlyTg1_u1_p0 @'h191 {
    field RxClkcDlyTg1_u1_p0 @0 {
       bits 6;
       access rw;
       reset 6'h10;
    }
  }
  register RxClkcDlyTg2_u1_p0 @'h192 {
    field RxClkcDlyTg2_u1_p0 @0 {
       bits 6;
       access rw;
       reset 6'h10;
    }
  }
  register RxClkcDlyTg3_u1_p0 @'h193 {
    field RxClkcDlyTg3_u1_p0 @0 {
       bits 6;
       access rw;
       reset 6'h10;
    }
  }
  register Tsm0_i1 @'h1b2 {
    field RFU_Tsm0_i1 @0 {
       bits 14;
       access rw;
       reset 14'h0;
    }
  }
  register Tsm1_i1 @'h1b3 {
    field RFU_Tsm1_i1 @0 {
       bits 16;
       access ro;
       reset 16'h0;
    }
  }
  register Tsm2_i1 @'h1b4 {
    field RFU_Tsm2_i1 @0 {
       bits 1;
       access rw;
       reset 1'h0;
    }
  }
  register TxDqDlyTg0_r1_p0 @'h1c0 {
    field TxDqDlyTg0_r1_p0 @0 {
       bits 9;
       access rw;
       reset 9'h10;
    }
  }
  register TxDqDlyTg1_r1_p0 @'h1c1 {
    field TxDqDlyTg1_r1_p0 @0 {
       bits 9;
       access rw;
       reset 9'h10;
    }
  }
  register TxDqDlyTg2_r1_p0 @'h1c2 {
    field TxDqDlyTg2_r1_p0 @0 {
       bits 9;
       access rw;
       reset 9'h10;
    }
  }
  register TxDqDlyTg3_r1_p0 @'h1c3 {
    field TxDqDlyTg3_r1_p0 @0 {
       bits 9;
       access rw;
       reset 9'h10;
    }
  }
  register TxDqsDlyTg0_u1_p0 @'h1d0 {
    field TxDqsDlyTg0_u1_p0 @0 {
       bits 10;
       access rw;
       reset 10'h100;
    }
  }
  register TxDqsDlyTg1_u1_p0 @'h1d1 {
    field TxDqsDlyTg1_u1_p0 @0 {
       bits 10;
       access rw;
       reset 10'h100;
    }
  }
  register TxDqsDlyTg2_u1_p0 @'h1d2 {
    field TxDqsDlyTg2_u1_p0 @0 {
       bits 10;
       access rw;
       reset 10'h100;
    }
  }
  register TxDqsDlyTg3_u1_p0 @'h1d3 {
    field TxDqsDlyTg3_u1_p0 @0 {
       bits 10;
       access rw;
       reset 10'h100;
    }
  }
  register VrefDAC1_r2 @'h230 {
    field VrefDAC1_r2 @0 {
       bits 7;
       access rw;
       reset 7'h0;
    }
  }
  register TrainingCntr_r2 @'h232 {
    field RFU_TrainingCntr_r2 @0 {
       bits 16;
       access rw;
       reset 16'h0;
    }
  }
  register VrefDAC0_r2 @'h240 {
    field VrefDAC0_r2 @0 {
       bits 7;
       access rw;
       reset 7'h0;
    }
  }
  register TrainingIncDecDtsmEn_r2 @'h262 {
    field TrainingIncDecDtsmEn_r2 @0 {
       bits 9;
       access rw;
       reset 9'h0;
    }
  }
  register RxPBDlyTg0_r2 @'h268 {
    field RxPBDlyTg0_r2 @0 {
       bits 7;
       access rw;
       reset 7'h0;
    }
  }
  register RxPBDlyTg1_r2 @'h269 {
    field RxPBDlyTg1_r2 @0 {
       bits 7;
       access rw;
       reset 7'h0;
    }
  }
  register RxPBDlyTg2_r2 @'h26a {
    field RxPBDlyTg2_r2 @0 {
       bits 7;
       access rw;
       reset 7'h0;
    }
  }
  register RxPBDlyTg3_r2 @'h26b {
    field RxPBDlyTg3_r2 @0 {
       bits 7;
       access rw;
       reset 7'h0;
    }
  }
  register Tsm0_i2 @'h2b2 {
    field RFU_Tsm0_i2 @0 {
       bits 14;
       access rw;
       reset 14'h0;
    }
  }
  register Tsm1_i2 @'h2b3 {
    field RFU_Tsm1_i2 @0 {
       bits 16;
       access ro;
       reset 16'h0;
    }
  }
  register Tsm2_i2 @'h2b4 {
    field RFU_Tsm2_i2 @0 {
       bits 1;
       access rw;
       reset 1'h0;
    }
  }
  register TxDqDlyTg0_r2_p0 @'h2c0 {
    field TxDqDlyTg0_r2_p0 @0 {
       bits 9;
       access rw;
       reset 9'h10;
    }
  }
  register TxDqDlyTg1_r2_p0 @'h2c1 {
    field TxDqDlyTg1_r2_p0 @0 {
       bits 9;
       access rw;
       reset 9'h10;
    }
  }
  register TxDqDlyTg2_r2_p0 @'h2c2 {
    field TxDqDlyTg2_r2_p0 @0 {
       bits 9;
       access rw;
       reset 9'h10;
    }
  }
  register TxDqDlyTg3_r2_p0 @'h2c3 {
    field TxDqDlyTg3_r2_p0 @0 {
       bits 9;
       access rw;
       reset 9'h10;
    }
  }
  register VrefDAC1_r3 @'h330 {
    field VrefDAC1_r3 @0 {
       bits 7;
       access rw;
       reset 7'h0;
    }
  }
  register TrainingCntr_r3 @'h332 {
    field RFU_TrainingCntr_r3 @0 {
       bits 16;
       access rw;
       reset 16'h0;
    }
  }
  register VrefDAC0_r3 @'h340 {
    field VrefDAC0_r3 @0 {
       bits 7;
       access rw;
       reset 7'h0;
    }
  }
  register TrainingIncDecDtsmEn_r3 @'h362 {
    field TrainingIncDecDtsmEn_r3 @0 {
       bits 9;
       access rw;
       reset 9'h0;
    }
  }
  register RxPBDlyTg0_r3 @'h368 {
    field RxPBDlyTg0_r3 @0 {
       bits 7;
       access rw;
       reset 7'h0;
    }
  }
  register RxPBDlyTg1_r3 @'h369 {
    field RxPBDlyTg1_r3 @0 {
       bits 7;
       access rw;
       reset 7'h0;
    }
  }
  register RxPBDlyTg2_r3 @'h36a {
    field RxPBDlyTg2_r3 @0 {
       bits 7;
       access rw;
       reset 7'h0;
    }
  }
  register RxPBDlyTg3_r3 @'h36b {
    field RxPBDlyTg3_r3 @0 {
       bits 7;
       access rw;
       reset 7'h0;
    }
  }
  register Tsm0_i3 @'h3b2 {
    field RFU_Tsm0_i3 @0 {
       bits 14;
       access rw;
       reset 14'h0;
    }
  }
  register Tsm1_i3 @'h3b3 {
    field RFU_Tsm1_i3 @0 {
       bits 16;
       access ro;
       reset 16'h0;
    }
  }
  register Tsm2_i3 @'h3b4 {
    field RFU_Tsm2_i3 @0 {
       bits 1;
       access rw;
       reset 1'h0;
    }
  }
  register TxDqDlyTg0_r3_p0 @'h3c0 {
    field TxDqDlyTg0_r3_p0 @0 {
       bits 9;
       access rw;
       reset 9'h10;
    }
  }
  register TxDqDlyTg1_r3_p0 @'h3c1 {
    field TxDqDlyTg1_r3_p0 @0 {
       bits 9;
       access rw;
       reset 9'h10;
    }
  }
  register TxDqDlyTg2_r3_p0 @'h3c2 {
    field TxDqDlyTg2_r3_p0 @0 {
       bits 9;
       access rw;
       reset 9'h10;
    }
  }
  register TxDqDlyTg3_r3_p0 @'h3c3 {
    field TxDqDlyTg3_r3_p0 @0 {
       bits 9;
       access rw;
       reset 9'h10;
    }
  }
  register VrefDAC1_r4 @'h430 {
    field VrefDAC1_r4 @0 {
       bits 7;
       access rw;
       reset 7'h0;
    }
  }
  register TrainingCntr_r4 @'h432 {
    field RFU_TrainingCntr_r4 @0 {
       bits 16;
       access rw;
       reset 16'h0;
    }
  }
  register VrefDAC0_r4 @'h440 {
    field VrefDAC0_r4 @0 {
       bits 7;
       access rw;
       reset 7'h0;
    }
  }
  register TrainingIncDecDtsmEn_r4 @'h462 {
    field TrainingIncDecDtsmEn_r4 @0 {
       bits 9;
       access rw;
       reset 9'h0;
    }
  }
  register RxPBDlyTg0_r4 @'h468 {
    field RxPBDlyTg0_r4 @0 {
       bits 7;
       access rw;
       reset 7'h0;
    }
  }
  register RxPBDlyTg1_r4 @'h469 {
    field RxPBDlyTg1_r4 @0 {
       bits 7;
       access rw;
       reset 7'h0;
    }
  }
  register RxPBDlyTg2_r4 @'h46a {
    field RxPBDlyTg2_r4 @0 {
       bits 7;
       access rw;
       reset 7'h0;
    }
  }
  register RxPBDlyTg3_r4 @'h46b {
    field RxPBDlyTg3_r4 @0 {
       bits 7;
       access rw;
       reset 7'h0;
    }
  }
  register Tsm0_i4 @'h4b2 {
    field RFU_Tsm0_i4 @0 {
       bits 14;
       access rw;
       reset 14'h0;
    }
  }
  register Tsm1_i4 @'h4b3 {
    field RFU_Tsm1_i4 @0 {
       bits 16;
       access ro;
       reset 16'h0;
    }
  }
  register Tsm2_i4 @'h4b4 {
    field RFU_Tsm2_i4 @0 {
       bits 1;
       access rw;
       reset 1'h0;
    }
  }
  register TxDqDlyTg0_r4_p0 @'h4c0 {
    field TxDqDlyTg0_r4_p0 @0 {
       bits 9;
       access rw;
       reset 9'h10;
    }
  }
  register TxDqDlyTg1_r4_p0 @'h4c1 {
    field TxDqDlyTg1_r4_p0 @0 {
       bits 9;
       access rw;
       reset 9'h10;
    }
  }
  register TxDqDlyTg2_r4_p0 @'h4c2 {
    field TxDqDlyTg2_r4_p0 @0 {
       bits 9;
       access rw;
       reset 9'h10;
    }
  }
  register TxDqDlyTg3_r4_p0 @'h4c3 {
    field TxDqDlyTg3_r4_p0 @0 {
       bits 9;
       access rw;
       reset 9'h10;
    }
  }
  register VrefDAC1_r5 @'h530 {
    field VrefDAC1_r5 @0 {
       bits 7;
       access rw;
       reset 7'h0;
    }
  }
  register TrainingCntr_r5 @'h532 {
    field RFU_TrainingCntr_r5 @0 {
       bits 16;
       access rw;
       reset 16'h0;
    }
  }
  register VrefDAC0_r5 @'h540 {
    field VrefDAC0_r5 @0 {
       bits 7;
       access rw;
       reset 7'h0;
    }
  }
  register TrainingIncDecDtsmEn_r5 @'h562 {
    field TrainingIncDecDtsmEn_r5 @0 {
       bits 9;
       access rw;
       reset 9'h0;
    }
  }
  register RxPBDlyTg0_r5 @'h568 {
    field RxPBDlyTg0_r5 @0 {
       bits 7;
       access rw;
       reset 7'h0;
    }
  }
  register RxPBDlyTg1_r5 @'h569 {
    field RxPBDlyTg1_r5 @0 {
       bits 7;
       access rw;
       reset 7'h0;
    }
  }
  register RxPBDlyTg2_r5 @'h56a {
    field RxPBDlyTg2_r5 @0 {
       bits 7;
       access rw;
       reset 7'h0;
    }
  }
  register RxPBDlyTg3_r5 @'h56b {
    field RxPBDlyTg3_r5 @0 {
       bits 7;
       access rw;
       reset 7'h0;
    }
  }
  register Tsm0_i5 @'h5b2 {
    field RFU_Tsm0_i5 @0 {
       bits 14;
       access rw;
       reset 14'h0;
    }
  }
  register Tsm1_i5 @'h5b3 {
    field RFU_Tsm1_i5 @0 {
       bits 16;
       access ro;
       reset 16'h0;
    }
  }
  register Tsm2_i5 @'h5b4 {
    field RFU_Tsm2_i5 @0 {
       bits 1;
       access rw;
       reset 1'h0;
    }
  }
  register TxDqDlyTg0_r5_p0 @'h5c0 {
    field TxDqDlyTg0_r5_p0 @0 {
       bits 9;
       access rw;
       reset 9'h10;
    }
  }
  register TxDqDlyTg1_r5_p0 @'h5c1 {
    field TxDqDlyTg1_r5_p0 @0 {
       bits 9;
       access rw;
       reset 9'h10;
    }
  }
  register TxDqDlyTg2_r5_p0 @'h5c2 {
    field TxDqDlyTg2_r5_p0 @0 {
       bits 9;
       access rw;
       reset 9'h10;
    }
  }
  register TxDqDlyTg3_r5_p0 @'h5c3 {
    field TxDqDlyTg3_r5_p0 @0 {
       bits 9;
       access rw;
       reset 9'h10;
    }
  }
  register VrefDAC1_r6 @'h630 {
    field VrefDAC1_r6 @0 {
       bits 7;
       access rw;
       reset 7'h0;
    }
  }
  register TrainingCntr_r6 @'h632 {
    field RFU_TrainingCntr_r6 @0 {
       bits 16;
       access rw;
       reset 16'h0;
    }
  }
  register VrefDAC0_r6 @'h640 {
    field VrefDAC0_r6 @0 {
       bits 7;
       access rw;
       reset 7'h0;
    }
  }
  register TrainingIncDecDtsmEn_r6 @'h662 {
    field TrainingIncDecDtsmEn_r6 @0 {
       bits 9;
       access rw;
       reset 9'h0;
    }
  }
  register RxPBDlyTg0_r6 @'h668 {
    field RxPBDlyTg0_r6 @0 {
       bits 7;
       access rw;
       reset 7'h0;
    }
  }
  register RxPBDlyTg1_r6 @'h669 {
    field RxPBDlyTg1_r6 @0 {
       bits 7;
       access rw;
       reset 7'h0;
    }
  }
  register RxPBDlyTg2_r6 @'h66a {
    field RxPBDlyTg2_r6 @0 {
       bits 7;
       access rw;
       reset 7'h0;
    }
  }
  register RxPBDlyTg3_r6 @'h66b {
    field RxPBDlyTg3_r6 @0 {
       bits 7;
       access rw;
       reset 7'h0;
    }
  }
  register Tsm0_i6 @'h6b2 {
    field RFU_Tsm0_i6 @0 {
       bits 14;
       access rw;
       reset 14'h0;
    }
  }
  register Tsm1_i6 @'h6b3 {
    field RFU_Tsm1_i6 @0 {
       bits 16;
       access ro;
       reset 16'h0;
    }
  }
  register Tsm2_i6 @'h6b4 {
    field RFU_Tsm2_i6 @0 {
       bits 1;
       access rw;
       reset 1'h0;
    }
  }
  register TxDqDlyTg0_r6_p0 @'h6c0 {
    field TxDqDlyTg0_r6_p0 @0 {
       bits 9;
       access rw;
       reset 9'h10;
    }
  }
  register TxDqDlyTg1_r6_p0 @'h6c1 {
    field TxDqDlyTg1_r6_p0 @0 {
       bits 9;
       access rw;
       reset 9'h10;
    }
  }
  register TxDqDlyTg2_r6_p0 @'h6c2 {
    field TxDqDlyTg2_r6_p0 @0 {
       bits 9;
       access rw;
       reset 9'h10;
    }
  }
  register TxDqDlyTg3_r6_p0 @'h6c3 {
    field TxDqDlyTg3_r6_p0 @0 {
       bits 9;
       access rw;
       reset 9'h10;
    }
  }
  register VrefDAC1_r7 @'h730 {
    field VrefDAC1_r7 @0 {
       bits 7;
       access rw;
       reset 7'h0;
    }
  }
  register TrainingCntr_r7 @'h732 {
    field RFU_TrainingCntr_r7 @0 {
       bits 16;
       access rw;
       reset 16'h0;
    }
  }
  register VrefDAC0_r7 @'h740 {
    field VrefDAC0_r7 @0 {
       bits 7;
       access rw;
       reset 7'h0;
    }
  }
  register TrainingIncDecDtsmEn_r7 @'h762 {
    field TrainingIncDecDtsmEn_r7 @0 {
       bits 9;
       access rw;
       reset 9'h0;
    }
  }
  register RxPBDlyTg0_r7 @'h768 {
    field RxPBDlyTg0_r7 @0 {
       bits 7;
       access rw;
       reset 7'h0;
    }
  }
  register RxPBDlyTg1_r7 @'h769 {
    field RxPBDlyTg1_r7 @0 {
       bits 7;
       access rw;
       reset 7'h0;
    }
  }
  register RxPBDlyTg2_r7 @'h76a {
    field RxPBDlyTg2_r7 @0 {
       bits 7;
       access rw;
       reset 7'h0;
    }
  }
  register RxPBDlyTg3_r7 @'h76b {
    field RxPBDlyTg3_r7 @0 {
       bits 7;
       access rw;
       reset 7'h0;
    }
  }
  register Tsm0_i7 @'h7b2 {
    field RFU_Tsm0_i7 @0 {
       bits 14;
       access rw;
       reset 14'h0;
    }
  }
  register Tsm1_i7 @'h7b3 {
    field RFU_Tsm1_i7 @0 {
       bits 16;
       access ro;
       reset 16'h0;
    }
  }
  register Tsm2_i7 @'h7b4 {
    field RFU_Tsm2_i7 @0 {
       bits 1;
       access rw;
       reset 1'h0;
    }
  }
  register TxDqDlyTg0_r7_p0 @'h7c0 {
    field TxDqDlyTg0_r7_p0 @0 {
       bits 9;
       access rw;
       reset 9'h10;
    }
  }
  register TxDqDlyTg1_r7_p0 @'h7c1 {
    field TxDqDlyTg1_r7_p0 @0 {
       bits 9;
       access rw;
       reset 9'h10;
    }
  }
  register TxDqDlyTg2_r7_p0 @'h7c2 {
    field TxDqDlyTg2_r7_p0 @0 {
       bits 9;
       access rw;
       reset 9'h10;
    }
  }
  register TxDqDlyTg3_r7_p0 @'h7c3 {
    field TxDqDlyTg3_r7_p0 @0 {
       bits 9;
       access rw;
       reset 9'h10;
    }
  }
  register VrefDAC1_r8 @'h830 {
    field VrefDAC1_r8 @0 {
       bits 7;
       access rw;
       reset 7'h0;
    }
  }
  register TrainingCntr_r8 @'h832 {
    field RFU_TrainingCntr_r8 @0 {
       bits 16;
       access rw;
       reset 16'h0;
    }
  }
  register VrefDAC0_r8 @'h840 {
    field VrefDAC0_r8 @0 {
       bits 7;
       access rw;
       reset 7'h0;
    }
  }
  register TrainingIncDecDtsmEn_r8 @'h862 {
    field TrainingIncDecDtsmEn_r8 @0 {
       bits 9;
       access rw;
       reset 9'h0;
    }
  }
  register RxPBDlyTg0_r8 @'h868 {
    field RxPBDlyTg0_r8 @0 {
       bits 7;
       access rw;
       reset 7'h0;
    }
  }
  register RxPBDlyTg1_r8 @'h869 {
    field RxPBDlyTg1_r8 @0 {
       bits 7;
       access rw;
       reset 7'h0;
    }
  }
  register RxPBDlyTg2_r8 @'h86a {
    field RxPBDlyTg2_r8 @0 {
       bits 7;
       access rw;
       reset 7'h0;
    }
  }
  register RxPBDlyTg3_r8 @'h86b {
    field RxPBDlyTg3_r8 @0 {
       bits 7;
       access rw;
       reset 7'h0;
    }
  }
  register Tsm0_i8 @'h8b2 {
    field RFU_Tsm0_i8 @0 {
       bits 14;
       access rw;
       reset 14'h0;
    }
  }
  register Tsm1_i8 @'h8b3 {
    field RFU_Tsm1_i8 @0 {
       bits 16;
       access ro;
       reset 16'h0;
    }
  }
  register Tsm2_i8 @'h8b4 {
    field RFU_Tsm2_i8 @0 {
       bits 1;
       access rw;
       reset 1'h0;
    }
  }
  register TxDqDlyTg0_r8_p0 @'h8c0 {
    field TxDqDlyTg0_r8_p0 @0 {
       bits 9;
       access rw;
       reset 9'h10;
    }
  }
  register TxDqDlyTg1_r8_p0 @'h8c1 {
    field TxDqDlyTg1_r8_p0 @0 {
       bits 9;
       access rw;
       reset 9'h10;
    }
  }
  register TxDqDlyTg2_r8_p0 @'h8c2 {
    field TxDqDlyTg2_r8_p0 @0 {
       bits 9;
       access rw;
       reset 9'h10;
    }
  }
  register TxDqDlyTg3_r8_p0 @'h8c3 {
    field TxDqDlyTg3_r8_p0 @0 {
       bits 9;
       access rw;
       reset 9'h10;
    }
  }
  register UseDqsEnReplica_p1 @'h100003 {
    field UseDqsEnReplica_p1 @0 {
       bits 1;
       access rw;
       reset 1'h0;
    }
  }
  register DFIMRL_p1 @'h100020 {
    field DFIMRL_p1 @0 {
       bits 5;
       access rw;
       reset 5'h6;
    }
  }
  register TxImpedanceCtrl0_b0_p1 @'h100041 {
    field DrvStrenDqP @0 {
       bits 6;
       access rw;
       reset 6'h3f;
    }
    field DrvStrenDqN @6 {
       bits 6;
       access rw;
       reset 6'h3f;
    }
  }
  register DqDqsRcvCntrl_b0_p1 @'h100043 {
    field SelAnalogVref @0 {
       bits 1;
       access rw;
       reset 1'h0;
    }
    field ExtVrefRange @1 {
       bits 1;
       access rw;
       reset 1'h0;
    }
    field DfeCtrl @2 {
       bits 2;
       access rw;
       reset 2'h0;
    }
    field MajorModeDbyte @4 {
       bits 3;
       access rw;
       reset 3'h3;
    }
    field GainCurrAdj @7 {
       bits 5;
       access rw;
       reset 5'hb;
    }
    field Reserved @12 {
       bits 4;
    }
  }
  register TxEqualizationMode_p1 @'h100048 {
    field TxEqMode @0 {
       bits 2;
       access rw;
       reset 2'h0;
    }
  }
  register TxImpedanceCtrl1_b0_p1 @'h100049 {
    field DrvStrenFSDqP @0 {
       bits 6;
       access rw;
       reset 6'h3f;
    }
    field DrvStrenFSDqN @6 {
       bits 6;
       access rw;
       reset 6'h3f;
    }
  }
  register TxImpedanceCtrl2_b0_p1 @'h10004b {
    field DrvStrenEQHiDqP @0 {
       bits 6;
       access rw;
       reset 6'h0;
    }
    field DrvStrenEQLoDqN @6 {
       bits 6;
       access rw;
       reset 6'h0;
    }
  }
  register DqDqsRcvCntrl2_p1 @'h10004c {
    field EnRxAgressivePDR @0 {
       bits 1;
       access rw;
       reset 1'h0;
    }
  }
  register TxOdtDrvStren_b0_p1 @'h10004d {
    field ODTStrenP @0 {
       bits 6;
       access rw;
       reset 6'h0;
    }
    field ODTStrenN @6 {
       bits 6;
       access rw;
       reset 6'h0;
    }
  }
  register TxSlewRate_b0_p1 @'h10005f {
    field TxPreP @0 {
       bits 4;
       access rw;
       reset 4'hf;
    }
    field TxPreN @4 {
       bits 4;
       access rw;
       reset 4'hf;
    }
    field TxPreDrvMode @8 {
       bits 3;
       access rw;
       reset 3'h7;
    }
  }
  register RxEnDlyTg0_u0_p1 @'h100080 {
    field RxEnDlyTg0_u0_p1 @0 {
       bits 11;
       access rw;
       reset 11'h100;
    }
  }
  register RxEnDlyTg1_u0_p1 @'h100081 {
    field RxEnDlyTg1_u0_p1 @0 {
       bits 11;
       access rw;
       reset 11'h100;
    }
  }
  register RxEnDlyTg2_u0_p1 @'h100082 {
    field RxEnDlyTg2_u0_p1 @0 {
       bits 11;
       access rw;
       reset 11'h100;
    }
  }
  register RxEnDlyTg3_u0_p1 @'h100083 {
    field RxEnDlyTg3_u0_p1 @0 {
       bits 11;
       access rw;
       reset 11'h100;
    }
  }
  register RxClkDlyTg0_u0_p1 @'h10008c {
    field RxClkDlyTg0_u0_p1 @0 {
       bits 6;
       access rw;
       reset 6'h10;
    }
  }
  register RxClkDlyTg1_u0_p1 @'h10008d {
    field RxClkDlyTg1_u0_p1 @0 {
       bits 6;
       access rw;
       reset 6'h10;
    }
  }
  register RxClkDlyTg2_u0_p1 @'h10008e {
    field RxClkDlyTg2_u0_p1 @0 {
       bits 6;
       access rw;
       reset 6'h10;
    }
  }
  register RxClkDlyTg3_u0_p1 @'h10008f {
    field RxClkDlyTg3_u0_p1 @0 {
       bits 6;
       access rw;
       reset 6'h10;
    }
  }
  register RxClkcDlyTg0_u0_p1 @'h100090 {
    field RxClkcDlyTg0_u0_p1 @0 {
       bits 6;
       access rw;
       reset 6'h10;
    }
  }
  register RxClkcDlyTg1_u0_p1 @'h100091 {
    field RxClkcDlyTg1_u0_p1 @0 {
       bits 6;
       access rw;
       reset 6'h10;
    }
  }
  register RxClkcDlyTg2_u0_p1 @'h100092 {
    field RxClkcDlyTg2_u0_p1 @0 {
       bits 6;
       access rw;
       reset 6'h10;
    }
  }
  register RxClkcDlyTg3_u0_p1 @'h100093 {
    field RxClkcDlyTg3_u0_p1 @0 {
       bits 6;
       access rw;
       reset 6'h10;
    }
  }
  register PptDqsCntInvTrnTg0_p1 @'h1000ae {
    field PptDqsCntInvTrnTg0_p1 @0 {
       bits 16;
       access rw;
       reset 16'h0;
    }
  }
  register PptDqsCntInvTrnTg1_p1 @'h1000af {
    field PptDqsCntInvTrnTg1_p1 @0 {
       bits 16;
       access rw;
       reset 16'h0;
    }
  }
  register TxDqDlyTg0_r0_p1 @'h1000c0 {
    field TxDqDlyTg0_r0_p1 @0 {
       bits 9;
       access rw;
       reset 9'h10;
    }
  }
  register TxDqDlyTg1_r0_p1 @'h1000c1 {
    field TxDqDlyTg1_r0_p1 @0 {
       bits 9;
       access rw;
       reset 9'h10;
    }
  }
  register TxDqDlyTg2_r0_p1 @'h1000c2 {
    field TxDqDlyTg2_r0_p1 @0 {
       bits 9;
       access rw;
       reset 9'h10;
    }
  }
  register TxDqDlyTg3_r0_p1 @'h1000c3 {
    field TxDqDlyTg3_r0_p1 @0 {
       bits 9;
       access rw;
       reset 9'h10;
    }
  }
  register TxDqsDlyTg0_u0_p1 @'h1000d0 {
    field TxDqsDlyTg0_u0_p1 @0 {
       bits 10;
       access rw;
       reset 10'h100;
    }
  }
  register TxDqsDlyTg1_u0_p1 @'h1000d1 {
    field TxDqsDlyTg1_u0_p1 @0 {
       bits 10;
       access rw;
       reset 10'h100;
    }
  }
  register TxDqsDlyTg2_u0_p1 @'h1000d2 {
    field TxDqsDlyTg2_u0_p1 @0 {
       bits 10;
       access rw;
       reset 10'h100;
    }
  }
  register TxDqsDlyTg3_u0_p1 @'h1000d3 {
    field TxDqsDlyTg3_u0_p1 @0 {
       bits 10;
       access rw;
       reset 10'h100;
    }
  }
  register TxImpedanceCtrl0_b1_p1 @'h100141 {
    field DrvStrenDqP @0 {
       bits 6;
       access rw;
       reset 6'h3f;
    }
    field DrvStrenDqN @6 {
       bits 6;
       access rw;
       reset 6'h3f;
    }
  }
  register DqDqsRcvCntrl_b1_p1 @'h100143 {
    field SelAnalogVref @0 {
       bits 1;
       access rw;
       reset 1'h0;
    }
    field ExtVrefRange @1 {
       bits 1;
       access rw;
       reset 1'h0;
    }
    field DfeCtrl @2 {
       bits 2;
       access rw;
       reset 2'h0;
    }
    field MajorModeDbyte @4 {
       bits 3;
       access rw;
       reset 3'h3;
    }
    field GainCurrAdj @7 {
       bits 5;
       access rw;
       reset 5'hb;
    }
    field Reserved @12 {
       bits 4;
    }
  }
  register TxImpedanceCtrl1_b1_p1 @'h100149 {
    field DrvStrenFSDqP @0 {
       bits 6;
       access rw;
       reset 6'h3f;
    }
    field DrvStrenFSDqN @6 {
       bits 6;
       access rw;
       reset 6'h3f;
    }
  }
  register TxImpedanceCtrl2_b1_p1 @'h10014b {
    field DrvStrenEQHiDqP @0 {
       bits 6;
       access rw;
       reset 6'h0;
    }
    field DrvStrenEQLoDqN @6 {
       bits 6;
       access rw;
       reset 6'h0;
    }
  }
  register TxOdtDrvStren_b1_p1 @'h10014d {
    field ODTStrenP @0 {
       bits 6;
       access rw;
       reset 6'h0;
    }
    field ODTStrenN @6 {
       bits 6;
       access rw;
       reset 6'h0;
    }
  }
  register TxSlewRate_b1_p1 @'h10015f {
    field TxPreP @0 {
       bits 4;
       access rw;
       reset 4'hf;
    }
    field TxPreN @4 {
       bits 4;
       access rw;
       reset 4'hf;
    }
    field TxPreDrvMode @8 {
       bits 3;
       access rw;
       reset 3'h7;
    }
  }
  register RxEnDlyTg0_u1_p1 @'h100180 {
    field RxEnDlyTg0_u1_p1 @0 {
       bits 11;
       access rw;
       reset 11'h100;
    }
  }
  register RxEnDlyTg1_u1_p1 @'h100181 {
    field RxEnDlyTg1_u1_p1 @0 {
       bits 11;
       access rw;
       reset 11'h100;
    }
  }
  register RxEnDlyTg2_u1_p1 @'h100182 {
    field RxEnDlyTg2_u1_p1 @0 {
       bits 11;
       access rw;
       reset 11'h100;
    }
  }
  register RxEnDlyTg3_u1_p1 @'h100183 {
    field RxEnDlyTg3_u1_p1 @0 {
       bits 11;
       access rw;
       reset 11'h100;
    }
  }
  register RxClkDlyTg0_u1_p1 @'h10018c {
    field RxClkDlyTg0_u1_p1 @0 {
       bits 6;
       access rw;
       reset 6'h10;
    }
  }
  register RxClkDlyTg1_u1_p1 @'h10018d {
    field RxClkDlyTg1_u1_p1 @0 {
       bits 6;
       access rw;
       reset 6'h10;
    }
  }
  register RxClkDlyTg2_u1_p1 @'h10018e {
    field RxClkDlyTg2_u1_p1 @0 {
       bits 6;
       access rw;
       reset 6'h10;
    }
  }
  register RxClkDlyTg3_u1_p1 @'h10018f {
    field RxClkDlyTg3_u1_p1 @0 {
       bits 6;
       access rw;
       reset 6'h10;
    }
  }
  register RxClkcDlyTg0_u1_p1 @'h100190 {
    field RxClkcDlyTg0_u1_p1 @0 {
       bits 6;
       access rw;
       reset 6'h10;
    }
  }
  register RxClkcDlyTg1_u1_p1 @'h100191 {
    field RxClkcDlyTg1_u1_p1 @0 {
       bits 6;
       access rw;
       reset 6'h10;
    }
  }
  register RxClkcDlyTg2_u1_p1 @'h100192 {
    field RxClkcDlyTg2_u1_p1 @0 {
       bits 6;
       access rw;
       reset 6'h10;
    }
  }
  register RxClkcDlyTg3_u1_p1 @'h100193 {
    field RxClkcDlyTg3_u1_p1 @0 {
       bits 6;
       access rw;
       reset 6'h10;
    }
  }
  register TxDqDlyTg0_r1_p1 @'h1001c0 {
    field TxDqDlyTg0_r1_p1 @0 {
       bits 9;
       access rw;
       reset 9'h10;
    }
  }
  register TxDqDlyTg1_r1_p1 @'h1001c1 {
    field TxDqDlyTg1_r1_p1 @0 {
       bits 9;
       access rw;
       reset 9'h10;
    }
  }
  register TxDqDlyTg2_r1_p1 @'h1001c2 {
    field TxDqDlyTg2_r1_p1 @0 {
       bits 9;
       access rw;
       reset 9'h10;
    }
  }
  register TxDqDlyTg3_r1_p1 @'h1001c3 {
    field TxDqDlyTg3_r1_p1 @0 {
       bits 9;
       access rw;
       reset 9'h10;
    }
  }
  register TxDqsDlyTg0_u1_p1 @'h1001d0 {
    field TxDqsDlyTg0_u1_p1 @0 {
       bits 10;
       access rw;
       reset 10'h100;
    }
  }
  register TxDqsDlyTg1_u1_p1 @'h1001d1 {
    field TxDqsDlyTg1_u1_p1 @0 {
       bits 10;
       access rw;
       reset 10'h100;
    }
  }
  register TxDqsDlyTg2_u1_p1 @'h1001d2 {
    field TxDqsDlyTg2_u1_p1 @0 {
       bits 10;
       access rw;
       reset 10'h100;
    }
  }
  register TxDqsDlyTg3_u1_p1 @'h1001d3 {
    field TxDqsDlyTg3_u1_p1 @0 {
       bits 10;
       access rw;
       reset 10'h100;
    }
  }
  register TxDqDlyTg0_r2_p1 @'h1002c0 {
    field TxDqDlyTg0_r2_p1 @0 {
       bits 9;
       access rw;
       reset 9'h10;
    }
  }
  register TxDqDlyTg1_r2_p1 @'h1002c1 {
    field TxDqDlyTg1_r2_p1 @0 {
       bits 9;
       access rw;
       reset 9'h10;
    }
  }
  register TxDqDlyTg2_r2_p1 @'h1002c2 {
    field TxDqDlyTg2_r2_p1 @0 {
       bits 9;
       access rw;
       reset 9'h10;
    }
  }
  register TxDqDlyTg3_r2_p1 @'h1002c3 {
    field TxDqDlyTg3_r2_p1 @0 {
       bits 9;
       access rw;
       reset 9'h10;
    }
  }
  register TxDqDlyTg0_r3_p1 @'h1003c0 {
    field TxDqDlyTg0_r3_p1 @0 {
       bits 9;
       access rw;
       reset 9'h10;
    }
  }
  register TxDqDlyTg1_r3_p1 @'h1003c1 {
    field TxDqDlyTg1_r3_p1 @0 {
       bits 9;
       access rw;
       reset 9'h10;
    }
  }
  register TxDqDlyTg2_r3_p1 @'h1003c2 {
    field TxDqDlyTg2_r3_p1 @0 {
       bits 9;
       access rw;
       reset 9'h10;
    }
  }
  register TxDqDlyTg3_r3_p1 @'h1003c3 {
    field TxDqDlyTg3_r3_p1 @0 {
       bits 9;
       access rw;
       reset 9'h10;
    }
  }
  register TxDqDlyTg0_r4_p1 @'h1004c0 {
    field TxDqDlyTg0_r4_p1 @0 {
       bits 9;
       access rw;
       reset 9'h10;
    }
  }
  register TxDqDlyTg1_r4_p1 @'h1004c1 {
    field TxDqDlyTg1_r4_p1 @0 {
       bits 9;
       access rw;
       reset 9'h10;
    }
  }
  register TxDqDlyTg2_r4_p1 @'h1004c2 {
    field TxDqDlyTg2_r4_p1 @0 {
       bits 9;
       access rw;
       reset 9'h10;
    }
  }
  register TxDqDlyTg3_r4_p1 @'h1004c3 {
    field TxDqDlyTg3_r4_p1 @0 {
       bits 9;
       access rw;
       reset 9'h10;
    }
  }
  register TxDqDlyTg0_r5_p1 @'h1005c0 {
    field TxDqDlyTg0_r5_p1 @0 {
       bits 9;
       access rw;
       reset 9'h10;
    }
  }
  register TxDqDlyTg1_r5_p1 @'h1005c1 {
    field TxDqDlyTg1_r5_p1 @0 {
       bits 9;
       access rw;
       reset 9'h10;
    }
  }
  register TxDqDlyTg2_r5_p1 @'h1005c2 {
    field TxDqDlyTg2_r5_p1 @0 {
       bits 9;
       access rw;
       reset 9'h10;
    }
  }
  register TxDqDlyTg3_r5_p1 @'h1005c3 {
    field TxDqDlyTg3_r5_p1 @0 {
       bits 9;
       access rw;
       reset 9'h10;
    }
  }
  register TxDqDlyTg0_r6_p1 @'h1006c0 {
    field TxDqDlyTg0_r6_p1 @0 {
       bits 9;
       access rw;
       reset 9'h10;
    }
  }
  register TxDqDlyTg1_r6_p1 @'h1006c1 {
    field TxDqDlyTg1_r6_p1 @0 {
       bits 9;
       access rw;
       reset 9'h10;
    }
  }
  register TxDqDlyTg2_r6_p1 @'h1006c2 {
    field TxDqDlyTg2_r6_p1 @0 {
       bits 9;
       access rw;
       reset 9'h10;
    }
  }
  register TxDqDlyTg3_r6_p1 @'h1006c3 {
    field TxDqDlyTg3_r6_p1 @0 {
       bits 9;
       access rw;
       reset 9'h10;
    }
  }
  register TxDqDlyTg0_r7_p1 @'h1007c0 {
    field TxDqDlyTg0_r7_p1 @0 {
       bits 9;
       access rw;
       reset 9'h10;
    }
  }
  register TxDqDlyTg1_r7_p1 @'h1007c1 {
    field TxDqDlyTg1_r7_p1 @0 {
       bits 9;
       access rw;
       reset 9'h10;
    }
  }
  register TxDqDlyTg2_r7_p1 @'h1007c2 {
    field TxDqDlyTg2_r7_p1 @0 {
       bits 9;
       access rw;
       reset 9'h10;
    }
  }
  register TxDqDlyTg3_r7_p1 @'h1007c3 {
    field TxDqDlyTg3_r7_p1 @0 {
       bits 9;
       access rw;
       reset 9'h10;
    }
  }
  register TxDqDlyTg0_r8_p1 @'h1008c0 {
    field TxDqDlyTg0_r8_p1 @0 {
       bits 9;
       access rw;
       reset 9'h10;
    }
  }
  register TxDqDlyTg1_r8_p1 @'h1008c1 {
    field TxDqDlyTg1_r8_p1 @0 {
       bits 9;
       access rw;
       reset 9'h10;
    }
  }
  register TxDqDlyTg2_r8_p1 @'h1008c2 {
    field TxDqDlyTg2_r8_p1 @0 {
       bits 9;
       access rw;
       reset 9'h10;
    }
  }
  register TxDqDlyTg3_r8_p1 @'h1008c3 {
    field TxDqDlyTg3_r8_p1 @0 {
       bits 9;
       access rw;
       reset 9'h10;
    }
  }
  register UseDqsEnReplica_p2 @'h200003 {
    field UseDqsEnReplica_p2 @0 {
       bits 1;
       access rw;
       reset 1'h0;
    }
  }
  register DFIMRL_p2 @'h200020 {
    field DFIMRL_p2 @0 {
       bits 5;
       access rw;
       reset 5'h6;
    }
  }
  register TxImpedanceCtrl0_b0_p2 @'h200041 {
    field DrvStrenDqP @0 {
       bits 6;
       access rw;
       reset 6'h3f;
    }
    field DrvStrenDqN @6 {
       bits 6;
       access rw;
       reset 6'h3f;
    }
  }
  register DqDqsRcvCntrl_b0_p2 @'h200043 {
    field SelAnalogVref @0 {
       bits 1;
       access rw;
       reset 1'h0;
    }
    field ExtVrefRange @1 {
       bits 1;
       access rw;
       reset 1'h0;
    }
    field DfeCtrl @2 {
       bits 2;
       access rw;
       reset 2'h0;
    }
    field MajorModeDbyte @4 {
       bits 3;
       access rw;
       reset 3'h3;
    }
    field GainCurrAdj @7 {
       bits 5;
       access rw;
       reset 5'hb;
    }
    field Reserved @12 {
       bits 4;
    }
  }
  register TxEqualizationMode_p2 @'h200048 {
    field TxEqMode @0 {
       bits 2;
       access rw;
       reset 2'h0;
    }
  }
  register TxImpedanceCtrl1_b0_p2 @'h200049 {
    field DrvStrenFSDqP @0 {
       bits 6;
       access rw;
       reset 6'h3f;
    }
    field DrvStrenFSDqN @6 {
       bits 6;
       access rw;
       reset 6'h3f;
    }
  }
  register TxImpedanceCtrl2_b0_p2 @'h20004b {
    field DrvStrenEQHiDqP @0 {
       bits 6;
       access rw;
       reset 6'h0;
    }
    field DrvStrenEQLoDqN @6 {
       bits 6;
       access rw;
       reset 6'h0;
    }
  }
  register DqDqsRcvCntrl2_p2 @'h20004c {
    field EnRxAgressivePDR @0 {
       bits 1;
       access rw;
       reset 1'h0;
    }
  }
  register TxOdtDrvStren_b0_p2 @'h20004d {
    field ODTStrenP @0 {
       bits 6;
       access rw;
       reset 6'h0;
    }
    field ODTStrenN @6 {
       bits 6;
       access rw;
       reset 6'h0;
    }
  }
  register TxSlewRate_b0_p2 @'h20005f {
    field TxPreP @0 {
       bits 4;
       access rw;
       reset 4'hf;
    }
    field TxPreN @4 {
       bits 4;
       access rw;
       reset 4'hf;
    }
    field TxPreDrvMode @8 {
       bits 3;
       access rw;
       reset 3'h7;
    }
  }
  register RxEnDlyTg0_u0_p2 @'h200080 {
    field RxEnDlyTg0_u0_p2 @0 {
       bits 11;
       access rw;
       reset 11'h100;
    }
  }
  register RxEnDlyTg1_u0_p2 @'h200081 {
    field RxEnDlyTg1_u0_p2 @0 {
       bits 11;
       access rw;
       reset 11'h100;
    }
  }
  register RxEnDlyTg2_u0_p2 @'h200082 {
    field RxEnDlyTg2_u0_p2 @0 {
       bits 11;
       access rw;
       reset 11'h100;
    }
  }
  register RxEnDlyTg3_u0_p2 @'h200083 {
    field RxEnDlyTg3_u0_p2 @0 {
       bits 11;
       access rw;
       reset 11'h100;
    }
  }
  register RxClkDlyTg0_u0_p2 @'h20008c {
    field RxClkDlyTg0_u0_p2 @0 {
       bits 6;
       access rw;
       reset 6'h10;
    }
  }
  register RxClkDlyTg1_u0_p2 @'h20008d {
    field RxClkDlyTg1_u0_p2 @0 {
       bits 6;
       access rw;
       reset 6'h10;
    }
  }
  register RxClkDlyTg2_u0_p2 @'h20008e {
    field RxClkDlyTg2_u0_p2 @0 {
       bits 6;
       access rw;
       reset 6'h10;
    }
  }
  register RxClkDlyTg3_u0_p2 @'h20008f {
    field RxClkDlyTg3_u0_p2 @0 {
       bits 6;
       access rw;
       reset 6'h10;
    }
  }
  register RxClkcDlyTg0_u0_p2 @'h200090 {
    field RxClkcDlyTg0_u0_p2 @0 {
       bits 6;
       access rw;
       reset 6'h10;
    }
  }
  register RxClkcDlyTg1_u0_p2 @'h200091 {
    field RxClkcDlyTg1_u0_p2 @0 {
       bits 6;
       access rw;
       reset 6'h10;
    }
  }
  register RxClkcDlyTg2_u0_p2 @'h200092 {
    field RxClkcDlyTg2_u0_p2 @0 {
       bits 6;
       access rw;
       reset 6'h10;
    }
  }
  register RxClkcDlyTg3_u0_p2 @'h200093 {
    field RxClkcDlyTg3_u0_p2 @0 {
       bits 6;
       access rw;
       reset 6'h10;
    }
  }
  register PptDqsCntInvTrnTg0_p2 @'h2000ae {
    field PptDqsCntInvTrnTg0_p2 @0 {
       bits 16;
       access rw;
       reset 16'h0;
    }
  }
  register PptDqsCntInvTrnTg1_p2 @'h2000af {
    field PptDqsCntInvTrnTg1_p2 @0 {
       bits 16;
       access rw;
       reset 16'h0;
    }
  }
  register TxDqDlyTg0_r0_p2 @'h2000c0 {
    field TxDqDlyTg0_r0_p2 @0 {
       bits 9;
       access rw;
       reset 9'h10;
    }
  }
  register TxDqDlyTg1_r0_p2 @'h2000c1 {
    field TxDqDlyTg1_r0_p2 @0 {
       bits 9;
       access rw;
       reset 9'h10;
    }
  }
  register TxDqDlyTg2_r0_p2 @'h2000c2 {
    field TxDqDlyTg2_r0_p2 @0 {
       bits 9;
       access rw;
       reset 9'h10;
    }
  }
  register TxDqDlyTg3_r0_p2 @'h2000c3 {
    field TxDqDlyTg3_r0_p2 @0 {
       bits 9;
       access rw;
       reset 9'h10;
    }
  }
  register TxDqsDlyTg0_u0_p2 @'h2000d0 {
    field TxDqsDlyTg0_u0_p2 @0 {
       bits 10;
       access rw;
       reset 10'h100;
    }
  }
  register TxDqsDlyTg1_u0_p2 @'h2000d1 {
    field TxDqsDlyTg1_u0_p2 @0 {
       bits 10;
       access rw;
       reset 10'h100;
    }
  }
  register TxDqsDlyTg2_u0_p2 @'h2000d2 {
    field TxDqsDlyTg2_u0_p2 @0 {
       bits 10;
       access rw;
       reset 10'h100;
    }
  }
  register TxDqsDlyTg3_u0_p2 @'h2000d3 {
    field TxDqsDlyTg3_u0_p2 @0 {
       bits 10;
       access rw;
       reset 10'h100;
    }
  }
  register TxImpedanceCtrl0_b1_p2 @'h200141 {
    field DrvStrenDqP @0 {
       bits 6;
       access rw;
       reset 6'h3f;
    }
    field DrvStrenDqN @6 {
       bits 6;
       access rw;
       reset 6'h3f;
    }
  }
  register DqDqsRcvCntrl_b1_p2 @'h200143 {
    field SelAnalogVref @0 {
       bits 1;
       access rw;
       reset 1'h0;
    }
    field ExtVrefRange @1 {
       bits 1;
       access rw;
       reset 1'h0;
    }
    field DfeCtrl @2 {
       bits 2;
       access rw;
       reset 2'h0;
    }
    field MajorModeDbyte @4 {
       bits 3;
       access rw;
       reset 3'h3;
    }
    field GainCurrAdj @7 {
       bits 5;
       access rw;
       reset 5'hb;
    }
    field Reserved @12 {
       bits 4;
    }
  }
  register TxImpedanceCtrl1_b1_p2 @'h200149 {
    field DrvStrenFSDqP @0 {
       bits 6;
       access rw;
       reset 6'h3f;
    }
    field DrvStrenFSDqN @6 {
       bits 6;
       access rw;
       reset 6'h3f;
    }
  }
  register TxImpedanceCtrl2_b1_p2 @'h20014b {
    field DrvStrenEQHiDqP @0 {
       bits 6;
       access rw;
       reset 6'h0;
    }
    field DrvStrenEQLoDqN @6 {
       bits 6;
       access rw;
       reset 6'h0;
    }
  }
  register TxOdtDrvStren_b1_p2 @'h20014d {
    field ODTStrenP @0 {
       bits 6;
       access rw;
       reset 6'h0;
    }
    field ODTStrenN @6 {
       bits 6;
       access rw;
       reset 6'h0;
    }
  }
  register TxSlewRate_b1_p2 @'h20015f {
    field TxPreP @0 {
       bits 4;
       access rw;
       reset 4'hf;
    }
    field TxPreN @4 {
       bits 4;
       access rw;
       reset 4'hf;
    }
    field TxPreDrvMode @8 {
       bits 3;
       access rw;
       reset 3'h7;
    }
  }
  register RxEnDlyTg0_u1_p2 @'h200180 {
    field RxEnDlyTg0_u1_p2 @0 {
       bits 11;
       access rw;
       reset 11'h100;
    }
  }
  register RxEnDlyTg1_u1_p2 @'h200181 {
    field RxEnDlyTg1_u1_p2 @0 {
       bits 11;
       access rw;
       reset 11'h100;
    }
  }
  register RxEnDlyTg2_u1_p2 @'h200182 {
    field RxEnDlyTg2_u1_p2 @0 {
       bits 11;
       access rw;
       reset 11'h100;
    }
  }
  register RxEnDlyTg3_u1_p2 @'h200183 {
    field RxEnDlyTg3_u1_p2 @0 {
       bits 11;
       access rw;
       reset 11'h100;
    }
  }
  register RxClkDlyTg0_u1_p2 @'h20018c {
    field RxClkDlyTg0_u1_p2 @0 {
       bits 6;
       access rw;
       reset 6'h10;
    }
  }
  register RxClkDlyTg1_u1_p2 @'h20018d {
    field RxClkDlyTg1_u1_p2 @0 {
       bits 6;
       access rw;
       reset 6'h10;
    }
  }
  register RxClkDlyTg2_u1_p2 @'h20018e {
    field RxClkDlyTg2_u1_p2 @0 {
       bits 6;
       access rw;
       reset 6'h10;
    }
  }
  register RxClkDlyTg3_u1_p2 @'h20018f {
    field RxClkDlyTg3_u1_p2 @0 {
       bits 6;
       access rw;
       reset 6'h10;
    }
  }
  register RxClkcDlyTg0_u1_p2 @'h200190 {
    field RxClkcDlyTg0_u1_p2 @0 {
       bits 6;
       access rw;
       reset 6'h10;
    }
  }
  register RxClkcDlyTg1_u1_p2 @'h200191 {
    field RxClkcDlyTg1_u1_p2 @0 {
       bits 6;
       access rw;
       reset 6'h10;
    }
  }
  register RxClkcDlyTg2_u1_p2 @'h200192 {
    field RxClkcDlyTg2_u1_p2 @0 {
       bits 6;
       access rw;
       reset 6'h10;
    }
  }
  register RxClkcDlyTg3_u1_p2 @'h200193 {
    field RxClkcDlyTg3_u1_p2 @0 {
       bits 6;
       access rw;
       reset 6'h10;
    }
  }
  register TxDqDlyTg0_r1_p2 @'h2001c0 {
    field TxDqDlyTg0_r1_p2 @0 {
       bits 9;
       access rw;
       reset 9'h10;
    }
  }
  register TxDqDlyTg1_r1_p2 @'h2001c1 {
    field TxDqDlyTg1_r1_p2 @0 {
       bits 9;
       access rw;
       reset 9'h10;
    }
  }
  register TxDqDlyTg2_r1_p2 @'h2001c2 {
    field TxDqDlyTg2_r1_p2 @0 {
       bits 9;
       access rw;
       reset 9'h10;
    }
  }
  register TxDqDlyTg3_r1_p2 @'h2001c3 {
    field TxDqDlyTg3_r1_p2 @0 {
       bits 9;
       access rw;
       reset 9'h10;
    }
  }
  register TxDqsDlyTg0_u1_p2 @'h2001d0 {
    field TxDqsDlyTg0_u1_p2 @0 {
       bits 10;
       access rw;
       reset 10'h100;
    }
  }
  register TxDqsDlyTg1_u1_p2 @'h2001d1 {
    field TxDqsDlyTg1_u1_p2 @0 {
       bits 10;
       access rw;
       reset 10'h100;
    }
  }
  register TxDqsDlyTg2_u1_p2 @'h2001d2 {
    field TxDqsDlyTg2_u1_p2 @0 {
       bits 10;
       access rw;
       reset 10'h100;
    }
  }
  register TxDqsDlyTg3_u1_p2 @'h2001d3 {
    field TxDqsDlyTg3_u1_p2 @0 {
       bits 10;
       access rw;
       reset 10'h100;
    }
  }
  register TxDqDlyTg0_r2_p2 @'h2002c0 {
    field TxDqDlyTg0_r2_p2 @0 {
       bits 9;
       access rw;
       reset 9'h10;
    }
  }
  register TxDqDlyTg1_r2_p2 @'h2002c1 {
    field TxDqDlyTg1_r2_p2 @0 {
       bits 9;
       access rw;
       reset 9'h10;
    }
  }
  register TxDqDlyTg2_r2_p2 @'h2002c2 {
    field TxDqDlyTg2_r2_p2 @0 {
       bits 9;
       access rw;
       reset 9'h10;
    }
  }
  register TxDqDlyTg3_r2_p2 @'h2002c3 {
    field TxDqDlyTg3_r2_p2 @0 {
       bits 9;
       access rw;
       reset 9'h10;
    }
  }
  register TxDqDlyTg0_r3_p2 @'h2003c0 {
    field TxDqDlyTg0_r3_p2 @0 {
       bits 9;
       access rw;
       reset 9'h10;
    }
  }
  register TxDqDlyTg1_r3_p2 @'h2003c1 {
    field TxDqDlyTg1_r3_p2 @0 {
       bits 9;
       access rw;
       reset 9'h10;
    }
  }
  register TxDqDlyTg2_r3_p2 @'h2003c2 {
    field TxDqDlyTg2_r3_p2 @0 {
       bits 9;
       access rw;
       reset 9'h10;
    }
  }
  register TxDqDlyTg3_r3_p2 @'h2003c3 {
    field TxDqDlyTg3_r3_p2 @0 {
       bits 9;
       access rw;
       reset 9'h10;
    }
  }
  register TxDqDlyTg0_r4_p2 @'h2004c0 {
    field TxDqDlyTg0_r4_p2 @0 {
       bits 9;
       access rw;
       reset 9'h10;
    }
  }
  register TxDqDlyTg1_r4_p2 @'h2004c1 {
    field TxDqDlyTg1_r4_p2 @0 {
       bits 9;
       access rw;
       reset 9'h10;
    }
  }
  register TxDqDlyTg2_r4_p2 @'h2004c2 {
    field TxDqDlyTg2_r4_p2 @0 {
       bits 9;
       access rw;
       reset 9'h10;
    }
  }
  register TxDqDlyTg3_r4_p2 @'h2004c3 {
    field TxDqDlyTg3_r4_p2 @0 {
       bits 9;
       access rw;
       reset 9'h10;
    }
  }
  register TxDqDlyTg0_r5_p2 @'h2005c0 {
    field TxDqDlyTg0_r5_p2 @0 {
       bits 9;
       access rw;
       reset 9'h10;
    }
  }
  register TxDqDlyTg1_r5_p2 @'h2005c1 {
    field TxDqDlyTg1_r5_p2 @0 {
       bits 9;
       access rw;
       reset 9'h10;
    }
  }
  register TxDqDlyTg2_r5_p2 @'h2005c2 {
    field TxDqDlyTg2_r5_p2 @0 {
       bits 9;
       access rw;
       reset 9'h10;
    }
  }
  register TxDqDlyTg3_r5_p2 @'h2005c3 {
    field TxDqDlyTg3_r5_p2 @0 {
       bits 9;
       access rw;
       reset 9'h10;
    }
  }
  register TxDqDlyTg0_r6_p2 @'h2006c0 {
    field TxDqDlyTg0_r6_p2 @0 {
       bits 9;
       access rw;
       reset 9'h10;
    }
  }
  register TxDqDlyTg1_r6_p2 @'h2006c1 {
    field TxDqDlyTg1_r6_p2 @0 {
       bits 9;
       access rw;
       reset 9'h10;
    }
  }
  register TxDqDlyTg2_r6_p2 @'h2006c2 {
    field TxDqDlyTg2_r6_p2 @0 {
       bits 9;
       access rw;
       reset 9'h10;
    }
  }
  register TxDqDlyTg3_r6_p2 @'h2006c3 {
    field TxDqDlyTg3_r6_p2 @0 {
       bits 9;
       access rw;
       reset 9'h10;
    }
  }
  register TxDqDlyTg0_r7_p2 @'h2007c0 {
    field TxDqDlyTg0_r7_p2 @0 {
       bits 9;
       access rw;
       reset 9'h10;
    }
  }
  register TxDqDlyTg1_r7_p2 @'h2007c1 {
    field TxDqDlyTg1_r7_p2 @0 {
       bits 9;
       access rw;
       reset 9'h10;
    }
  }
  register TxDqDlyTg2_r7_p2 @'h2007c2 {
    field TxDqDlyTg2_r7_p2 @0 {
       bits 9;
       access rw;
       reset 9'h10;
    }
  }
  register TxDqDlyTg3_r7_p2 @'h2007c3 {
    field TxDqDlyTg3_r7_p2 @0 {
       bits 9;
       access rw;
       reset 9'h10;
    }
  }
  register TxDqDlyTg0_r8_p2 @'h2008c0 {
    field TxDqDlyTg0_r8_p2 @0 {
       bits 9;
       access rw;
       reset 9'h10;
    }
  }
  register TxDqDlyTg1_r8_p2 @'h2008c1 {
    field TxDqDlyTg1_r8_p2 @0 {
       bits 9;
       access rw;
       reset 9'h10;
    }
  }
  register TxDqDlyTg2_r8_p2 @'h2008c2 {
    field TxDqDlyTg2_r8_p2 @0 {
       bits 9;
       access rw;
       reset 9'h10;
    }
  }
  register TxDqDlyTg3_r8_p2 @'h2008c3 {
    field TxDqDlyTg3_r8_p2 @0 {
       bits 9;
       access rw;
       reset 9'h10;
    }
  }
  register UseDqsEnReplica_p3 @'h300003 {
    field UseDqsEnReplica_p3 @0 {
       bits 1;
       access rw;
       reset 1'h0;
    }
  }
  register DFIMRL_p3 @'h300020 {
    field DFIMRL_p3 @0 {
       bits 5;
       access rw;
       reset 5'h6;
    }
  }
  register TxImpedanceCtrl0_b0_p3 @'h300041 {
    field DrvStrenDqP @0 {
       bits 6;
       access rw;
       reset 6'h3f;
    }
    field DrvStrenDqN @6 {
       bits 6;
       access rw;
       reset 6'h3f;
    }
  }
  register DqDqsRcvCntrl_b0_p3 @'h300043 {
    field SelAnalogVref @0 {
       bits 1;
       access rw;
       reset 1'h0;
    }
    field ExtVrefRange @1 {
       bits 1;
       access rw;
       reset 1'h0;
    }
    field DfeCtrl @2 {
       bits 2;
       access rw;
       reset 2'h0;
    }
    field MajorModeDbyte @4 {
       bits 3;
       access rw;
       reset 3'h3;
    }
    field GainCurrAdj @7 {
       bits 5;
       access rw;
       reset 5'hb;
    }
    field Reserved @12 {
       bits 4;
    }
  }
  register TxEqualizationMode_p3 @'h300048 {
    field TxEqMode @0 {
       bits 2;
       access rw;
       reset 2'h0;
    }
  }
  register TxImpedanceCtrl1_b0_p3 @'h300049 {
    field DrvStrenFSDqP @0 {
       bits 6;
       access rw;
       reset 6'h3f;
    }
    field DrvStrenFSDqN @6 {
       bits 6;
       access rw;
       reset 6'h3f;
    }
  }
  register TxImpedanceCtrl2_b0_p3 @'h30004b {
    field DrvStrenEQHiDqP @0 {
       bits 6;
       access rw;
       reset 6'h0;
    }
    field DrvStrenEQLoDqN @6 {
       bits 6;
       access rw;
       reset 6'h0;
    }
  }
  register DqDqsRcvCntrl2_p3 @'h30004c {
    field EnRxAgressivePDR @0 {
       bits 1;
       access rw;
       reset 1'h0;
    }
  }
  register TxOdtDrvStren_b0_p3 @'h30004d {
    field ODTStrenP @0 {
       bits 6;
       access rw;
       reset 6'h0;
    }
    field ODTStrenN @6 {
       bits 6;
       access rw;
       reset 6'h0;
    }
  }
  register TxSlewRate_b0_p3 @'h30005f {
    field TxPreP @0 {
       bits 4;
       access rw;
       reset 4'hf;
    }
    field TxPreN @4 {
       bits 4;
       access rw;
       reset 4'hf;
    }
    field TxPreDrvMode @8 {
       bits 3;
       access rw;
       reset 3'h7;
    }
  }
  register RxEnDlyTg0_u0_p3 @'h300080 {
    field RxEnDlyTg0_u0_p3 @0 {
       bits 11;
       access rw;
       reset 11'h100;
    }
  }
  register RxEnDlyTg1_u0_p3 @'h300081 {
    field RxEnDlyTg1_u0_p3 @0 {
       bits 11;
       access rw;
       reset 11'h100;
    }
  }
  register RxEnDlyTg2_u0_p3 @'h300082 {
    field RxEnDlyTg2_u0_p3 @0 {
       bits 11;
       access rw;
       reset 11'h100;
    }
  }
  register RxEnDlyTg3_u0_p3 @'h300083 {
    field RxEnDlyTg3_u0_p3 @0 {
       bits 11;
       access rw;
       reset 11'h100;
    }
  }
  register RxClkDlyTg0_u0_p3 @'h30008c {
    field RxClkDlyTg0_u0_p3 @0 {
       bits 6;
       access rw;
       reset 6'h10;
    }
  }
  register RxClkDlyTg1_u0_p3 @'h30008d {
    field RxClkDlyTg1_u0_p3 @0 {
       bits 6;
       access rw;
       reset 6'h10;
    }
  }
  register RxClkDlyTg2_u0_p3 @'h30008e {
    field RxClkDlyTg2_u0_p3 @0 {
       bits 6;
       access rw;
       reset 6'h10;
    }
  }
  register RxClkDlyTg3_u0_p3 @'h30008f {
    field RxClkDlyTg3_u0_p3 @0 {
       bits 6;
       access rw;
       reset 6'h10;
    }
  }
  register RxClkcDlyTg0_u0_p3 @'h300090 {
    field RxClkcDlyTg0_u0_p3 @0 {
       bits 6;
       access rw;
       reset 6'h10;
    }
  }
  register RxClkcDlyTg1_u0_p3 @'h300091 {
    field RxClkcDlyTg1_u0_p3 @0 {
       bits 6;
       access rw;
       reset 6'h10;
    }
  }
  register RxClkcDlyTg2_u0_p3 @'h300092 {
    field RxClkcDlyTg2_u0_p3 @0 {
       bits 6;
       access rw;
       reset 6'h10;
    }
  }
  register RxClkcDlyTg3_u0_p3 @'h300093 {
    field RxClkcDlyTg3_u0_p3 @0 {
       bits 6;
       access rw;
       reset 6'h10;
    }
  }
  register PptDqsCntInvTrnTg0_p3 @'h3000ae {
    field PptDqsCntInvTrnTg0_p3 @0 {
       bits 16;
       access rw;
       reset 16'h0;
    }
  }
  register PptDqsCntInvTrnTg1_p3 @'h3000af {
    field PptDqsCntInvTrnTg1_p3 @0 {
       bits 16;
       access rw;
       reset 16'h0;
    }
  }
  register TxDqDlyTg0_r0_p3 @'h3000c0 {
    field TxDqDlyTg0_r0_p3 @0 {
       bits 9;
       access rw;
       reset 9'h10;
    }
  }
  register TxDqDlyTg1_r0_p3 @'h3000c1 {
    field TxDqDlyTg1_r0_p3 @0 {
       bits 9;
       access rw;
       reset 9'h10;
    }
  }
  register TxDqDlyTg2_r0_p3 @'h3000c2 {
    field TxDqDlyTg2_r0_p3 @0 {
       bits 9;
       access rw;
       reset 9'h10;
    }
  }
  register TxDqDlyTg3_r0_p3 @'h3000c3 {
    field TxDqDlyTg3_r0_p3 @0 {
       bits 9;
       access rw;
       reset 9'h10;
    }
  }
  register TxDqsDlyTg0_u0_p3 @'h3000d0 {
    field TxDqsDlyTg0_u0_p3 @0 {
       bits 10;
       access rw;
       reset 10'h100;
    }
  }
  register TxDqsDlyTg1_u0_p3 @'h3000d1 {
    field TxDqsDlyTg1_u0_p3 @0 {
       bits 10;
       access rw;
       reset 10'h100;
    }
  }
  register TxDqsDlyTg2_u0_p3 @'h3000d2 {
    field TxDqsDlyTg2_u0_p3 @0 {
       bits 10;
       access rw;
       reset 10'h100;
    }
  }
  register TxDqsDlyTg3_u0_p3 @'h3000d3 {
    field TxDqsDlyTg3_u0_p3 @0 {
       bits 10;
       access rw;
       reset 10'h100;
    }
  }
  register TxImpedanceCtrl0_b1_p3 @'h300141 {
    field DrvStrenDqP @0 {
       bits 6;
       access rw;
       reset 6'h3f;
    }
    field DrvStrenDqN @6 {
       bits 6;
       access rw;
       reset 6'h3f;
    }
  }
  register DqDqsRcvCntrl_b1_p3 @'h300143 {
    field SelAnalogVref @0 {
       bits 1;
       access rw;
       reset 1'h0;
    }
    field ExtVrefRange @1 {
       bits 1;
       access rw;
       reset 1'h0;
    }
    field DfeCtrl @2 {
       bits 2;
       access rw;
       reset 2'h0;
    }
    field MajorModeDbyte @4 {
       bits 3;
       access rw;
       reset 3'h3;
    }
    field GainCurrAdj @7 {
       bits 5;
       access rw;
       reset 5'hb;
    }
    field Reserved @12 {
       bits 4;
    }
  }
  register TxImpedanceCtrl1_b1_p3 @'h300149 {
    field DrvStrenFSDqP @0 {
       bits 6;
       access rw;
       reset 6'h3f;
    }
    field DrvStrenFSDqN @6 {
       bits 6;
       access rw;
       reset 6'h3f;
    }
  }
  register TxImpedanceCtrl2_b1_p3 @'h30014b {
    field DrvStrenEQHiDqP @0 {
       bits 6;
       access rw;
       reset 6'h0;
    }
    field DrvStrenEQLoDqN @6 {
       bits 6;
       access rw;
       reset 6'h0;
    }
  }
  register TxOdtDrvStren_b1_p3 @'h30014d {
    field ODTStrenP @0 {
       bits 6;
       access rw;
       reset 6'h0;
    }
    field ODTStrenN @6 {
       bits 6;
       access rw;
       reset 6'h0;
    }
  }
  register TxSlewRate_b1_p3 @'h30015f {
    field TxPreP @0 {
       bits 4;
       access rw;
       reset 4'hf;
    }
    field TxPreN @4 {
       bits 4;
       access rw;
       reset 4'hf;
    }
    field TxPreDrvMode @8 {
       bits 3;
       access rw;
       reset 3'h7;
    }
  }
  register RxEnDlyTg0_u1_p3 @'h300180 {
    field RxEnDlyTg0_u1_p3 @0 {
       bits 11;
       access rw;
       reset 11'h100;
    }
  }
  register RxEnDlyTg1_u1_p3 @'h300181 {
    field RxEnDlyTg1_u1_p3 @0 {
       bits 11;
       access rw;
       reset 11'h100;
    }
  }
  register RxEnDlyTg2_u1_p3 @'h300182 {
    field RxEnDlyTg2_u1_p3 @0 {
       bits 11;
       access rw;
       reset 11'h100;
    }
  }
  register RxEnDlyTg3_u1_p3 @'h300183 {
    field RxEnDlyTg3_u1_p3 @0 {
       bits 11;
       access rw;
       reset 11'h100;
    }
  }
  register RxClkDlyTg0_u1_p3 @'h30018c {
    field RxClkDlyTg0_u1_p3 @0 {
       bits 6;
       access rw;
       reset 6'h10;
    }
  }
  register RxClkDlyTg1_u1_p3 @'h30018d {
    field RxClkDlyTg1_u1_p3 @0 {
       bits 6;
       access rw;
       reset 6'h10;
    }
  }
  register RxClkDlyTg2_u1_p3 @'h30018e {
    field RxClkDlyTg2_u1_p3 @0 {
       bits 6;
       access rw;
       reset 6'h10;
    }
  }
  register RxClkDlyTg3_u1_p3 @'h30018f {
    field RxClkDlyTg3_u1_p3 @0 {
       bits 6;
       access rw;
       reset 6'h10;
    }
  }
  register RxClkcDlyTg0_u1_p3 @'h300190 {
    field RxClkcDlyTg0_u1_p3 @0 {
       bits 6;
       access rw;
       reset 6'h10;
    }
  }
  register RxClkcDlyTg1_u1_p3 @'h300191 {
    field RxClkcDlyTg1_u1_p3 @0 {
       bits 6;
       access rw;
       reset 6'h10;
    }
  }
  register RxClkcDlyTg2_u1_p3 @'h300192 {
    field RxClkcDlyTg2_u1_p3 @0 {
       bits 6;
       access rw;
       reset 6'h10;
    }
  }
  register RxClkcDlyTg3_u1_p3 @'h300193 {
    field RxClkcDlyTg3_u1_p3 @0 {
       bits 6;
       access rw;
       reset 6'h10;
    }
  }
  register TxDqDlyTg0_r1_p3 @'h3001c0 {
    field TxDqDlyTg0_r1_p3 @0 {
       bits 9;
       access rw;
       reset 9'h10;
    }
  }
  register TxDqDlyTg1_r1_p3 @'h3001c1 {
    field TxDqDlyTg1_r1_p3 @0 {
       bits 9;
       access rw;
       reset 9'h10;
    }
  }
  register TxDqDlyTg2_r1_p3 @'h3001c2 {
    field TxDqDlyTg2_r1_p3 @0 {
       bits 9;
       access rw;
       reset 9'h10;
    }
  }
  register TxDqDlyTg3_r1_p3 @'h3001c3 {
    field TxDqDlyTg3_r1_p3 @0 {
       bits 9;
       access rw;
       reset 9'h10;
    }
  }
  register TxDqsDlyTg0_u1_p3 @'h3001d0 {
    field TxDqsDlyTg0_u1_p3 @0 {
       bits 10;
       access rw;
       reset 10'h100;
    }
  }
  register TxDqsDlyTg1_u1_p3 @'h3001d1 {
    field TxDqsDlyTg1_u1_p3 @0 {
       bits 10;
       access rw;
       reset 10'h100;
    }
  }
  register TxDqsDlyTg2_u1_p3 @'h3001d2 {
    field TxDqsDlyTg2_u1_p3 @0 {
       bits 10;
       access rw;
       reset 10'h100;
    }
  }
  register TxDqsDlyTg3_u1_p3 @'h3001d3 {
    field TxDqsDlyTg3_u1_p3 @0 {
       bits 10;
       access rw;
       reset 10'h100;
    }
  }
  register TxDqDlyTg0_r2_p3 @'h3002c0 {
    field TxDqDlyTg0_r2_p3 @0 {
       bits 9;
       access rw;
       reset 9'h10;
    }
  }
  register TxDqDlyTg1_r2_p3 @'h3002c1 {
    field TxDqDlyTg1_r2_p3 @0 {
       bits 9;
       access rw;
       reset 9'h10;
    }
  }
  register TxDqDlyTg2_r2_p3 @'h3002c2 {
    field TxDqDlyTg2_r2_p3 @0 {
       bits 9;
       access rw;
       reset 9'h10;
    }
  }
  register TxDqDlyTg3_r2_p3 @'h3002c3 {
    field TxDqDlyTg3_r2_p3 @0 {
       bits 9;
       access rw;
       reset 9'h10;
    }
  }
  register TxDqDlyTg0_r3_p3 @'h3003c0 {
    field TxDqDlyTg0_r3_p3 @0 {
       bits 9;
       access rw;
       reset 9'h10;
    }
  }
  register TxDqDlyTg1_r3_p3 @'h3003c1 {
    field TxDqDlyTg1_r3_p3 @0 {
       bits 9;
       access rw;
       reset 9'h10;
    }
  }
  register TxDqDlyTg2_r3_p3 @'h3003c2 {
    field TxDqDlyTg2_r3_p3 @0 {
       bits 9;
       access rw;
       reset 9'h10;
    }
  }
  register TxDqDlyTg3_r3_p3 @'h3003c3 {
    field TxDqDlyTg3_r3_p3 @0 {
       bits 9;
       access rw;
       reset 9'h10;
    }
  }
  register TxDqDlyTg0_r4_p3 @'h3004c0 {
    field TxDqDlyTg0_r4_p3 @0 {
       bits 9;
       access rw;
       reset 9'h10;
    }
  }
  register TxDqDlyTg1_r4_p3 @'h3004c1 {
    field TxDqDlyTg1_r4_p3 @0 {
       bits 9;
       access rw;
       reset 9'h10;
    }
  }
  register TxDqDlyTg2_r4_p3 @'h3004c2 {
    field TxDqDlyTg2_r4_p3 @0 {
       bits 9;
       access rw;
       reset 9'h10;
    }
  }
  register TxDqDlyTg3_r4_p3 @'h3004c3 {
    field TxDqDlyTg3_r4_p3 @0 {
       bits 9;
       access rw;
       reset 9'h10;
    }
  }
  register TxDqDlyTg0_r5_p3 @'h3005c0 {
    field TxDqDlyTg0_r5_p3 @0 {
       bits 9;
       access rw;
       reset 9'h10;
    }
  }
  register TxDqDlyTg1_r5_p3 @'h3005c1 {
    field TxDqDlyTg1_r5_p3 @0 {
       bits 9;
       access rw;
       reset 9'h10;
    }
  }
  register TxDqDlyTg2_r5_p3 @'h3005c2 {
    field TxDqDlyTg2_r5_p3 @0 {
       bits 9;
       access rw;
       reset 9'h10;
    }
  }
  register TxDqDlyTg3_r5_p3 @'h3005c3 {
    field TxDqDlyTg3_r5_p3 @0 {
       bits 9;
       access rw;
       reset 9'h10;
    }
  }
  register TxDqDlyTg0_r6_p3 @'h3006c0 {
    field TxDqDlyTg0_r6_p3 @0 {
       bits 9;
       access rw;
       reset 9'h10;
    }
  }
  register TxDqDlyTg1_r6_p3 @'h3006c1 {
    field TxDqDlyTg1_r6_p3 @0 {
       bits 9;
       access rw;
       reset 9'h10;
    }
  }
  register TxDqDlyTg2_r6_p3 @'h3006c2 {
    field TxDqDlyTg2_r6_p3 @0 {
       bits 9;
       access rw;
       reset 9'h10;
    }
  }
  register TxDqDlyTg3_r6_p3 @'h3006c3 {
    field TxDqDlyTg3_r6_p3 @0 {
       bits 9;
       access rw;
       reset 9'h10;
    }
  }
  register TxDqDlyTg0_r7_p3 @'h3007c0 {
    field TxDqDlyTg0_r7_p3 @0 {
       bits 9;
       access rw;
       reset 9'h10;
    }
  }
  register TxDqDlyTg1_r7_p3 @'h3007c1 {
    field TxDqDlyTg1_r7_p3 @0 {
       bits 9;
       access rw;
       reset 9'h10;
    }
  }
  register TxDqDlyTg2_r7_p3 @'h3007c2 {
    field TxDqDlyTg2_r7_p3 @0 {
       bits 9;
       access rw;
       reset 9'h10;
    }
  }
  register TxDqDlyTg3_r7_p3 @'h3007c3 {
    field TxDqDlyTg3_r7_p3 @0 {
       bits 9;
       access rw;
       reset 9'h10;
    }
  }
  register TxDqDlyTg0_r8_p3 @'h3008c0 {
    field TxDqDlyTg0_r8_p3 @0 {
       bits 9;
       access rw;
       reset 9'h10;
    }
  }
  register TxDqDlyTg1_r8_p3 @'h3008c1 {
    field TxDqDlyTg1_r8_p3 @0 {
       bits 9;
       access rw;
       reset 9'h10;
    }
  }
  register TxDqDlyTg2_r8_p3 @'h3008c2 {
    field TxDqDlyTg2_r8_p3 @0 {
       bits 9;
       access rw;
       reset 9'h10;
    }
  }
  register TxDqDlyTg3_r8_p3 @'h3008c3 {
    field TxDqDlyTg3_r8_p3 @0 {
       bits 9;
       access rw;
       reset 9'h10;
    }
  }
}
block dwc_ddrphy_top_DWC_DDRPHYA_DBYTE3 {
  endian little;
  bytes 2;
  register DbyteMiscMode @'h0 {
    field Reserved @0 {
       bits 2;
    }
    field DByteDisable @2 {
       bits 1;
       access rw;
       reset 1'h0;
    }
  }
  register TsmByte0 @'h1 {
    field RFU_TsmByte0 @0 {
       bits 16;
       access rw;
       reset 16'h0;
    }
  }
  register TrainingParam @'h2 {
    field RFU_TrainingParam @0 {
       bits 16;
       access rw;
       reset 16'h0;
    }
  }
  register UseDqsEnReplica_p0 @'h3 {
    field UseDqsEnReplica_p0 @0 {
       bits 1;
       access rw;
       reset 1'h0;
    }
  }
  register RxTrainPatternEnable @'h10 {
    field RxTrainPatternEnable @0 {
       bits 1;
       access rw;
       reset 1'h0;
    }
  }
  register TsmByte1 @'h11 {
    field RFU_TsmByte1 @0 {
       bits 16;
       access rw;
       reset 16'h0;
    }
  }
  register TsmByte2 @'h12 {
    field RFU_TsmByte2 @0 {
       bits 16;
       access rw;
       reset 16'h0;
    }
  }
  register TsmByte3 @'h13 {
    field RFU_TsmByte3 @0 {
       bits 9;
       access rw;
       reset 9'h0;
    }
  }
  register TsmByte4 @'h14 {
    field RFU_TsmByte4 @0 {
       bits 4;
       access rw;
       reset 4'h0;
    }
  }
  register TestModeConfig @'h17 {
    field RFU_TestModeConfig @0 {
       bits 10;
       access rw;
       reset 10'h0;
    }
  }
  register TsmByte5 @'h18 {
    field RFU_TsmByte5 @0 {
       bits 16;
       access rw;
       reset 16'h0;
    }
  }
  register MtestMuxSel @'h1a {
    field MtestMuxSel @0 {
       bits 6;
       access rw;
       reset 6'h0;
    }
  }
  register DtsmTrainModeCtrl @'h1f {
    field RFU_DtsmTrainModeCtrl @0 {
       bits 4;
       access rw;
       reset 4'h0;
    }
  }
  register DFIMRL_p0 @'h20 {
    field DFIMRL_p0 @0 {
       bits 5;
       access rw;
       reset 5'h6;
    }
  }
  register AsyncDbyteMode @'h24 {
    field AsyncDbyteMode @0 {
       bits 9;
       access rw;
       reset 9'h0;
    }
  }
  register AsyncDbyteTxEn @'h26 {
    field AsyncDbyteTxEn @0 {
       bits 12;
       access rw;
       reset 12'h0;
    }
  }
  register AsyncDbyteTxData @'h28 {
    field AsyncDbyteTxData @0 {
       bits 12;
       access rw;
       reset 12'h0;
    }
  }
  register AsyncDbyteRxData @'h2a {
    field AsyncDbyteRxData @0 {
       bits 12;
       access ro;
       reset 12'h0;
    }
  }
  register VrefDAC1_r0 @'h30 {
    field VrefDAC1_r0 @0 {
       bits 7;
       access rw;
       reset 7'h0;
    }
  }
  register TrainingCntr_r0 @'h32 {
    field RFU_TrainingCntr_r0 @0 {
       bits 16;
       access rw;
       reset 16'h0;
    }
  }
  register VrefDAC0_r0 @'h40 {
    field VrefDAC0_r0 @0 {
       bits 7;
       access rw;
       reset 7'h0;
    }
  }
  register TxImpedanceCtrl0_b0_p0 @'h41 {
    field DrvStrenDqP @0 {
       bits 6;
       access rw;
       reset 6'h3f;
    }
    field DrvStrenDqN @6 {
       bits 6;
       access rw;
       reset 6'h3f;
    }
  }
  register DqDqsRcvCntrl_b0_p0 @'h43 {
    field SelAnalogVref @0 {
       bits 1;
       access rw;
       reset 1'h0;
    }
    field ExtVrefRange @1 {
       bits 1;
       access rw;
       reset 1'h0;
    }
    field DfeCtrl @2 {
       bits 2;
       access rw;
       reset 2'h0;
    }
    field MajorModeDbyte @4 {
       bits 3;
       access rw;
       reset 3'h3;
    }
    field GainCurrAdj @7 {
       bits 5;
       access rw;
       reset 5'hb;
    }
    field Reserved @12 {
       bits 4;
    }
  }
  register TxEqualizationMode_p0 @'h48 {
    field TxEqMode @0 {
       bits 2;
       access rw;
       reset 2'h0;
    }
  }
  register TxImpedanceCtrl1_b0_p0 @'h49 {
    field DrvStrenFSDqP @0 {
       bits 6;
       access rw;
       reset 6'h3f;
    }
    field DrvStrenFSDqN @6 {
       bits 6;
       access rw;
       reset 6'h3f;
    }
  }
  register DqDqsRcvCntrl1 @'h4a {
    field PowerDownRcvr @0 {
       bits 9;
       access rw;
       reset 9'h0;
    }
    field PowerDownRcvrDqs @9 {
       bits 1;
       access rw;
       reset 1'h0;
    }
    field RxPadStandbyEn @10 {
       bits 1;
       access rw;
       reset 1'h1;
    }
    field EnLPReqPDR @11 {
       bits 1;
       access rw;
       reset 1'h0;
    }
  }
  register TxImpedanceCtrl2_b0_p0 @'h4b {
    field DrvStrenEQHiDqP @0 {
       bits 6;
       access rw;
       reset 6'h0;
    }
    field DrvStrenEQLoDqN @6 {
       bits 6;
       access rw;
       reset 6'h0;
    }
  }
  register DqDqsRcvCntrl2_p0 @'h4c {
    field EnRxAgressivePDR @0 {
       bits 1;
       access rw;
       reset 1'h0;
    }
  }
  register TxOdtDrvStren_b0_p0 @'h4d {
    field ODTStrenP @0 {
       bits 6;
       access rw;
       reset 6'h0;
    }
    field ODTStrenN @6 {
       bits 6;
       access rw;
       reset 6'h0;
    }
  }
  register RxFifoCheckStatus @'h56 {
    field RxFifoLocErr @0 {
       bits 1;
       access ro;
       reset 1'h0;
    }
    field RxFifoLocUErr @1 {
       bits 1;
       access ro;
       reset 1'h0;
    }
  }
  register RxFifoCheckErrValues @'h57 {
    field RxFifoRdLocErrValue @0 {
       bits 4;
       access ro;
       reset 4'h0;
    }
    field RxFifoWrLocErrValue @4 {
       bits 4;
       access ro;
       reset 4'h0;
    }
    field RxFifoRdLocUErrValue @8 {
       bits 4;
       access ro;
       reset 4'h0;
    }
    field RxFifoWrLocUErrValue @12 {
       bits 4;
       access ro;
       reset 4'h0;
    }
  }
  register RxFifoInfo @'h58 {
    field RxFifoRdLoc @0 {
       bits 4;
       access ro;
       reset 4'h0;
    }
    field RxFifoWrLoc @4 {
       bits 4;
       access ro;
       reset 4'h0;
    }
    field RxFifoRdLocU @8 {
       bits 4;
       access ro;
       reset 4'h0;
    }
    field RxFifoWrLocU @12 {
       bits 4;
       access ro;
       reset 4'h0;
    }
  }
  register RxFifoVisibility @'h59 {
    field RxFifoRdPtr @0 {
       bits 3;
       access rw;
       reset 3'h0;
    }
    field RxFifoRdPtrOvr @3 {
       bits 1;
       access rw;
       reset 1'h0;
    }
    field RxFifoRdEn @4 {
       bits 1;
       access rw;
       reset 1'h0;
    }
  }
  register RxFifoContentsDQ3210 @'h5a {
    field RxFifoContentsDQ3210 @0 {
       bits 16;
       access ro;
       reset 16'h0;
    }
  }
  register RxFifoContentsDQ7654 @'h5b {
    field RxFifoContentsDQ7654 @0 {
       bits 16;
       access ro;
       reset 16'h0;
    }
  }
  register RxFifoContentsDBI @'h5c {
    field RxFifoContentsDBI @0 {
       bits 4;
       access ro;
       reset 4'h0;
    }
  }
  register TxSlewRate_b0_p0 @'h5f {
    field TxPreP @0 {
       bits 4;
       access rw;
       reset 4'hf;
    }
    field TxPreN @4 {
       bits 4;
       access rw;
       reset 4'hf;
    }
    field TxPreDrvMode @8 {
       bits 3;
       access rw;
       reset 3'h7;
    }
  }
  register TrainingIncDecDtsmEn_r0 @'h62 {
    field TrainingIncDecDtsmEn_r0 @0 {
       bits 9;
       access rw;
       reset 9'h0;
    }
  }
  register RxPBDlyTg0_r0 @'h68 {
    field RxPBDlyTg0_r0 @0 {
       bits 7;
       access rw;
       reset 7'h0;
    }
  }
  register RxPBDlyTg1_r0 @'h69 {
    field RxPBDlyTg1_r0 @0 {
       bits 7;
       access rw;
       reset 7'h0;
    }
  }
  register RxPBDlyTg2_r0 @'h6a {
    field RxPBDlyTg2_r0 @0 {
       bits 7;
       access rw;
       reset 7'h0;
    }
  }
  register RxPBDlyTg3_r0 @'h6b {
    field RxPBDlyTg3_r0 @0 {
       bits 7;
       access rw;
       reset 7'h0;
    }
  }
  register RxEnDlyTg0_u0_p0 @'h80 {
    field RxEnDlyTg0_u0_p0 @0 {
       bits 11;
       access rw;
       reset 11'h100;
    }
  }
  register RxEnDlyTg1_u0_p0 @'h81 {
    field RxEnDlyTg1_u0_p0 @0 {
       bits 11;
       access rw;
       reset 11'h100;
    }
  }
  register RxEnDlyTg2_u0_p0 @'h82 {
    field RxEnDlyTg2_u0_p0 @0 {
       bits 11;
       access rw;
       reset 11'h100;
    }
  }
  register RxEnDlyTg3_u0_p0 @'h83 {
    field RxEnDlyTg3_u0_p0 @0 {
       bits 11;
       access rw;
       reset 11'h100;
    }
  }
  register RxClkDlyTg0_u0_p0 @'h8c {
    field RxClkDlyTg0_u0_p0 @0 {
       bits 6;
       access rw;
       reset 6'h10;
    }
  }
  register RxClkDlyTg1_u0_p0 @'h8d {
    field RxClkDlyTg1_u0_p0 @0 {
       bits 6;
       access rw;
       reset 6'h10;
    }
  }
  register RxClkDlyTg2_u0_p0 @'h8e {
    field RxClkDlyTg2_u0_p0 @0 {
       bits 6;
       access rw;
       reset 6'h10;
    }
  }
  register RxClkDlyTg3_u0_p0 @'h8f {
    field RxClkDlyTg3_u0_p0 @0 {
       bits 6;
       access rw;
       reset 6'h10;
    }
  }
  register RxClkcDlyTg0_u0_p0 @'h90 {
    field RxClkcDlyTg0_u0_p0 @0 {
       bits 6;
       access rw;
       reset 6'h10;
    }
  }
  register RxClkcDlyTg1_u0_p0 @'h91 {
    field RxClkcDlyTg1_u0_p0 @0 {
       bits 6;
       access rw;
       reset 6'h10;
    }
  }
  register RxClkcDlyTg2_u0_p0 @'h92 {
    field RxClkcDlyTg2_u0_p0 @0 {
       bits 6;
       access rw;
       reset 6'h10;
    }
  }
  register RxClkcDlyTg3_u0_p0 @'h93 {
    field RxClkcDlyTg3_u0_p0 @0 {
       bits 6;
       access rw;
       reset 6'h10;
    }
  }
  register Dq0LnSel @'ha0 {
    field Dq0LnSel @0 {
       bits 3;
       access rw;
       reset 3'h0;
    }
  }
  register Dq1LnSel @'ha1 {
    field Dq1LnSel @0 {
       bits 3;
       access rw;
       reset 3'h1;
    }
  }
  register Dq2LnSel @'ha2 {
    field Dq2LnSel @0 {
       bits 3;
       access rw;
       reset 3'h2;
    }
  }
  register Dq3LnSel @'ha3 {
    field Dq3LnSel @0 {
       bits 3;
       access rw;
       reset 3'h3;
    }
  }
  register Dq4LnSel @'ha4 {
    field Dq4LnSel @0 {
       bits 3;
       access rw;
       reset 3'h4;
    }
  }
  register Dq5LnSel @'ha5 {
    field Dq5LnSel @0 {
       bits 3;
       access rw;
       reset 3'h5;
    }
  }
  register Dq6LnSel @'ha6 {
    field Dq6LnSel @0 {
       bits 3;
       access rw;
       reset 3'h6;
    }
  }
  register Dq7LnSel @'ha7 {
    field Dq7LnSel @0 {
       bits 3;
       access rw;
       reset 3'h7;
    }
  }
  register PptCtlStatic @'haa {
    field RFU_PptCtlStatic @0 {
       bits 12;
       access rw;
       reset 12'h0;
    }
  }
  register PptCtlDyn @'hab {
    field RFU_PptCtlDyn @0 {
       bits 2;
       access rw;
       reset 2'h0;
    }
  }
  register PptInfo @'hac {
    field PptInfo @0 {
       bits 16;
       access ro;
       reset 16'h0;
    }
  }
  register PptRxEnEvnt @'had {
    field RFU_PptRxEnEvnt @0 {
       bits 2;
       access rw;
       reset 2'h0;
    }
  }
  register PptDqsCntInvTrnTg0_p0 @'hae {
    field PptDqsCntInvTrnTg0_p0 @0 {
       bits 16;
       access rw;
       reset 16'h0;
    }
  }
  register PptDqsCntInvTrnTg1_p0 @'haf {
    field PptDqsCntInvTrnTg1_p0 @0 {
       bits 16;
       access rw;
       reset 16'h0;
    }
  }
  register DtsmBlankingCtrl @'hb1 {
    field RFU_DtsmBlankingCtrl @0 {
       bits 10;
       access rw;
       reset 10'h0;
    }
  }
  register Tsm0_i0 @'hb2 {
    field RFU_Tsm0_i0 @0 {
       bits 14;
       access rw;
       reset 14'h0;
    }
  }
  register Tsm1_i0 @'hb3 {
    field RFU_Tsm1_i0 @0 {
       bits 16;
       access ro;
       reset 16'h0;
    }
  }
  register Tsm2_i0 @'hb4 {
    field RFU_Tsm2_i0 @0 {
       bits 1;
       access rw;
       reset 1'h0;
    }
  }
  register Tsm3 @'hb5 {
    field RFU_Tsm3 @0 {
       bits 10;
       access rw;
       reset 10'h0;
    }
  }
  register TxChkDataSelects @'hb6 {
    field RFU_TxChkDataSelects @0 {
       bits 2;
       access rw;
       reset 2'h0;
    }
  }
  register DtsmUpThldXingInd @'hb7 {
    field DtsmUpThldXingInd @0 {
       bits 9;
       access ro;
       reset 9'h0;
    }
  }
  register DtsmLoThldXingInd @'hb8 {
    field DtsmLoThldXingInd @0 {
       bits 9;
       access ro;
       reset 9'h0;
    }
  }
  register DbyteAllDtsmCtrl0 @'hb9 {
    field RFU_DbyteAllDtsmCtrl0 @0 {
       bits 9;
       access rw;
       reset 9'h0;
    }
  }
  register DbyteAllDtsmCtrl1 @'hba {
    field RFU_DbyteAllDtsmCtrl1 @0 {
       bits 9;
       access rw;
       reset 9'h0;
    }
  }
  register DbyteAllDtsmCtrl2 @'hbb {
    field RFU_DbyteAllDtsmCtrl2 @0 {
       bits 9;
       access rw;
       reset 9'h0;
    }
  }
  register TxDqDlyTg0_r0_p0 @'hc0 {
    field TxDqDlyTg0_r0_p0 @0 {
       bits 9;
       access rw;
       reset 9'h10;
    }
  }
  register TxDqDlyTg1_r0_p0 @'hc1 {
    field TxDqDlyTg1_r0_p0 @0 {
       bits 9;
       access rw;
       reset 9'h10;
    }
  }
  register TxDqDlyTg2_r0_p0 @'hc2 {
    field TxDqDlyTg2_r0_p0 @0 {
       bits 9;
       access rw;
       reset 9'h10;
    }
  }
  register TxDqDlyTg3_r0_p0 @'hc3 {
    field TxDqDlyTg3_r0_p0 @0 {
       bits 9;
       access rw;
       reset 9'h10;
    }
  }
  register TxDqsDlyTg0_u0_p0 @'hd0 {
    field TxDqsDlyTg0_u0_p0 @0 {
       bits 10;
       access rw;
       reset 10'h100;
    }
  }
  register TxDqsDlyTg1_u0_p0 @'hd1 {
    field TxDqsDlyTg1_u0_p0 @0 {
       bits 10;
       access rw;
       reset 10'h100;
    }
  }
  register TxDqsDlyTg2_u0_p0 @'hd2 {
    field TxDqsDlyTg2_u0_p0 @0 {
       bits 10;
       access rw;
       reset 10'h100;
    }
  }
  register TxDqsDlyTg3_u0_p0 @'hd3 {
    field TxDqsDlyTg3_u0_p0 @0 {
       bits 10;
       access rw;
       reset 10'h100;
    }
  }
  register DxLcdlStatus @'he4 {
    field DxLcdlFineSnapVal @0 {
       bits 10;
       access ro;
       reset 10'h0;
    }
    field DxLcdlPhdSnapVal @10 {
       bits 1;
       access ro;
       reset 1'h0;
    }
    field DxLcdlStickyLock @11 {
       bits 1;
       access ro;
       reset 1'h0;
    }
    field DxLcdlStickyUnlock @12 {
       bits 1;
       access ro;
       reset 1'h0;
    }
    field DxLcdlLiveLock @13 {
       bits 1;
       access ro;
       reset 1'h0;
    }
  }
  register VrefDAC1_r1 @'h130 {
    field VrefDAC1_r1 @0 {
       bits 7;
       access rw;
       reset 7'h0;
    }
  }
  register TrainingCntr_r1 @'h132 {
    field RFU_TrainingCntr_r1 @0 {
       bits 16;
       access rw;
       reset 16'h0;
    }
  }
  register VrefDAC0_r1 @'h140 {
    field VrefDAC0_r1 @0 {
       bits 7;
       access rw;
       reset 7'h0;
    }
  }
  register TxImpedanceCtrl0_b1_p0 @'h141 {
    field DrvStrenDqP @0 {
       bits 6;
       access rw;
       reset 6'h3f;
    }
    field DrvStrenDqN @6 {
       bits 6;
       access rw;
       reset 6'h3f;
    }
  }
  register DqDqsRcvCntrl_b1_p0 @'h143 {
    field SelAnalogVref @0 {
       bits 1;
       access rw;
       reset 1'h0;
    }
    field ExtVrefRange @1 {
       bits 1;
       access rw;
       reset 1'h0;
    }
    field DfeCtrl @2 {
       bits 2;
       access rw;
       reset 2'h0;
    }
    field MajorModeDbyte @4 {
       bits 3;
       access rw;
       reset 3'h3;
    }
    field GainCurrAdj @7 {
       bits 5;
       access rw;
       reset 5'hb;
    }
    field Reserved @12 {
       bits 4;
    }
  }
  register TxImpedanceCtrl1_b1_p0 @'h149 {
    field DrvStrenFSDqP @0 {
       bits 6;
       access rw;
       reset 6'h3f;
    }
    field DrvStrenFSDqN @6 {
       bits 6;
       access rw;
       reset 6'h3f;
    }
  }
  register TxImpedanceCtrl2_b1_p0 @'h14b {
    field DrvStrenEQHiDqP @0 {
       bits 6;
       access rw;
       reset 6'h0;
    }
    field DrvStrenEQLoDqN @6 {
       bits 6;
       access rw;
       reset 6'h0;
    }
  }
  register TxOdtDrvStren_b1_p0 @'h14d {
    field ODTStrenP @0 {
       bits 6;
       access rw;
       reset 6'h0;
    }
    field ODTStrenN @6 {
       bits 6;
       access rw;
       reset 6'h0;
    }
  }
  register TxSlewRate_b1_p0 @'h15f {
    field TxPreP @0 {
       bits 4;
       access rw;
       reset 4'hf;
    }
    field TxPreN @4 {
       bits 4;
       access rw;
       reset 4'hf;
    }
    field TxPreDrvMode @8 {
       bits 3;
       access rw;
       reset 3'h7;
    }
  }
  register TrainingIncDecDtsmEn_r1 @'h162 {
    field TrainingIncDecDtsmEn_r1 @0 {
       bits 9;
       access rw;
       reset 9'h0;
    }
  }
  register RxPBDlyTg0_r1 @'h168 {
    field RxPBDlyTg0_r1 @0 {
       bits 7;
       access rw;
       reset 7'h0;
    }
  }
  register RxPBDlyTg1_r1 @'h169 {
    field RxPBDlyTg1_r1 @0 {
       bits 7;
       access rw;
       reset 7'h0;
    }
  }
  register RxPBDlyTg2_r1 @'h16a {
    field RxPBDlyTg2_r1 @0 {
       bits 7;
       access rw;
       reset 7'h0;
    }
  }
  register RxPBDlyTg3_r1 @'h16b {
    field RxPBDlyTg3_r1 @0 {
       bits 7;
       access rw;
       reset 7'h0;
    }
  }
  register RxEnDlyTg0_u1_p0 @'h180 {
    field RxEnDlyTg0_u1_p0 @0 {
       bits 11;
       access rw;
       reset 11'h100;
    }
  }
  register RxEnDlyTg1_u1_p0 @'h181 {
    field RxEnDlyTg1_u1_p0 @0 {
       bits 11;
       access rw;
       reset 11'h100;
    }
  }
  register RxEnDlyTg2_u1_p0 @'h182 {
    field RxEnDlyTg2_u1_p0 @0 {
       bits 11;
       access rw;
       reset 11'h100;
    }
  }
  register RxEnDlyTg3_u1_p0 @'h183 {
    field RxEnDlyTg3_u1_p0 @0 {
       bits 11;
       access rw;
       reset 11'h100;
    }
  }
  register RxClkDlyTg0_u1_p0 @'h18c {
    field RxClkDlyTg0_u1_p0 @0 {
       bits 6;
       access rw;
       reset 6'h10;
    }
  }
  register RxClkDlyTg1_u1_p0 @'h18d {
    field RxClkDlyTg1_u1_p0 @0 {
       bits 6;
       access rw;
       reset 6'h10;
    }
  }
  register RxClkDlyTg2_u1_p0 @'h18e {
    field RxClkDlyTg2_u1_p0 @0 {
       bits 6;
       access rw;
       reset 6'h10;
    }
  }
  register RxClkDlyTg3_u1_p0 @'h18f {
    field RxClkDlyTg3_u1_p0 @0 {
       bits 6;
       access rw;
       reset 6'h10;
    }
  }
  register RxClkcDlyTg0_u1_p0 @'h190 {
    field RxClkcDlyTg0_u1_p0 @0 {
       bits 6;
       access rw;
       reset 6'h10;
    }
  }
  register RxClkcDlyTg1_u1_p0 @'h191 {
    field RxClkcDlyTg1_u1_p0 @0 {
       bits 6;
       access rw;
       reset 6'h10;
    }
  }
  register RxClkcDlyTg2_u1_p0 @'h192 {
    field RxClkcDlyTg2_u1_p0 @0 {
       bits 6;
       access rw;
       reset 6'h10;
    }
  }
  register RxClkcDlyTg3_u1_p0 @'h193 {
    field RxClkcDlyTg3_u1_p0 @0 {
       bits 6;
       access rw;
       reset 6'h10;
    }
  }
  register Tsm0_i1 @'h1b2 {
    field RFU_Tsm0_i1 @0 {
       bits 14;
       access rw;
       reset 14'h0;
    }
  }
  register Tsm1_i1 @'h1b3 {
    field RFU_Tsm1_i1 @0 {
       bits 16;
       access ro;
       reset 16'h0;
    }
  }
  register Tsm2_i1 @'h1b4 {
    field RFU_Tsm2_i1 @0 {
       bits 1;
       access rw;
       reset 1'h0;
    }
  }
  register TxDqDlyTg0_r1_p0 @'h1c0 {
    field TxDqDlyTg0_r1_p0 @0 {
       bits 9;
       access rw;
       reset 9'h10;
    }
  }
  register TxDqDlyTg1_r1_p0 @'h1c1 {
    field TxDqDlyTg1_r1_p0 @0 {
       bits 9;
       access rw;
       reset 9'h10;
    }
  }
  register TxDqDlyTg2_r1_p0 @'h1c2 {
    field TxDqDlyTg2_r1_p0 @0 {
       bits 9;
       access rw;
       reset 9'h10;
    }
  }
  register TxDqDlyTg3_r1_p0 @'h1c3 {
    field TxDqDlyTg3_r1_p0 @0 {
       bits 9;
       access rw;
       reset 9'h10;
    }
  }
  register TxDqsDlyTg0_u1_p0 @'h1d0 {
    field TxDqsDlyTg0_u1_p0 @0 {
       bits 10;
       access rw;
       reset 10'h100;
    }
  }
  register TxDqsDlyTg1_u1_p0 @'h1d1 {
    field TxDqsDlyTg1_u1_p0 @0 {
       bits 10;
       access rw;
       reset 10'h100;
    }
  }
  register TxDqsDlyTg2_u1_p0 @'h1d2 {
    field TxDqsDlyTg2_u1_p0 @0 {
       bits 10;
       access rw;
       reset 10'h100;
    }
  }
  register TxDqsDlyTg3_u1_p0 @'h1d3 {
    field TxDqsDlyTg3_u1_p0 @0 {
       bits 10;
       access rw;
       reset 10'h100;
    }
  }
  register VrefDAC1_r2 @'h230 {
    field VrefDAC1_r2 @0 {
       bits 7;
       access rw;
       reset 7'h0;
    }
  }
  register TrainingCntr_r2 @'h232 {
    field RFU_TrainingCntr_r2 @0 {
       bits 16;
       access rw;
       reset 16'h0;
    }
  }
  register VrefDAC0_r2 @'h240 {
    field VrefDAC0_r2 @0 {
       bits 7;
       access rw;
       reset 7'h0;
    }
  }
  register TrainingIncDecDtsmEn_r2 @'h262 {
    field TrainingIncDecDtsmEn_r2 @0 {
       bits 9;
       access rw;
       reset 9'h0;
    }
  }
  register RxPBDlyTg0_r2 @'h268 {
    field RxPBDlyTg0_r2 @0 {
       bits 7;
       access rw;
       reset 7'h0;
    }
  }
  register RxPBDlyTg1_r2 @'h269 {
    field RxPBDlyTg1_r2 @0 {
       bits 7;
       access rw;
       reset 7'h0;
    }
  }
  register RxPBDlyTg2_r2 @'h26a {
    field RxPBDlyTg2_r2 @0 {
       bits 7;
       access rw;
       reset 7'h0;
    }
  }
  register RxPBDlyTg3_r2 @'h26b {
    field RxPBDlyTg3_r2 @0 {
       bits 7;
       access rw;
       reset 7'h0;
    }
  }
  register Tsm0_i2 @'h2b2 {
    field RFU_Tsm0_i2 @0 {
       bits 14;
       access rw;
       reset 14'h0;
    }
  }
  register Tsm1_i2 @'h2b3 {
    field RFU_Tsm1_i2 @0 {
       bits 16;
       access ro;
       reset 16'h0;
    }
  }
  register Tsm2_i2 @'h2b4 {
    field RFU_Tsm2_i2 @0 {
       bits 1;
       access rw;
       reset 1'h0;
    }
  }
  register TxDqDlyTg0_r2_p0 @'h2c0 {
    field TxDqDlyTg0_r2_p0 @0 {
       bits 9;
       access rw;
       reset 9'h10;
    }
  }
  register TxDqDlyTg1_r2_p0 @'h2c1 {
    field TxDqDlyTg1_r2_p0 @0 {
       bits 9;
       access rw;
       reset 9'h10;
    }
  }
  register TxDqDlyTg2_r2_p0 @'h2c2 {
    field TxDqDlyTg2_r2_p0 @0 {
       bits 9;
       access rw;
       reset 9'h10;
    }
  }
  register TxDqDlyTg3_r2_p0 @'h2c3 {
    field TxDqDlyTg3_r2_p0 @0 {
       bits 9;
       access rw;
       reset 9'h10;
    }
  }
  register VrefDAC1_r3 @'h330 {
    field VrefDAC1_r3 @0 {
       bits 7;
       access rw;
       reset 7'h0;
    }
  }
  register TrainingCntr_r3 @'h332 {
    field RFU_TrainingCntr_r3 @0 {
       bits 16;
       access rw;
       reset 16'h0;
    }
  }
  register VrefDAC0_r3 @'h340 {
    field VrefDAC0_r3 @0 {
       bits 7;
       access rw;
       reset 7'h0;
    }
  }
  register TrainingIncDecDtsmEn_r3 @'h362 {
    field TrainingIncDecDtsmEn_r3 @0 {
       bits 9;
       access rw;
       reset 9'h0;
    }
  }
  register RxPBDlyTg0_r3 @'h368 {
    field RxPBDlyTg0_r3 @0 {
       bits 7;
       access rw;
       reset 7'h0;
    }
  }
  register RxPBDlyTg1_r3 @'h369 {
    field RxPBDlyTg1_r3 @0 {
       bits 7;
       access rw;
       reset 7'h0;
    }
  }
  register RxPBDlyTg2_r3 @'h36a {
    field RxPBDlyTg2_r3 @0 {
       bits 7;
       access rw;
       reset 7'h0;
    }
  }
  register RxPBDlyTg3_r3 @'h36b {
    field RxPBDlyTg3_r3 @0 {
       bits 7;
       access rw;
       reset 7'h0;
    }
  }
  register Tsm0_i3 @'h3b2 {
    field RFU_Tsm0_i3 @0 {
       bits 14;
       access rw;
       reset 14'h0;
    }
  }
  register Tsm1_i3 @'h3b3 {
    field RFU_Tsm1_i3 @0 {
       bits 16;
       access ro;
       reset 16'h0;
    }
  }
  register Tsm2_i3 @'h3b4 {
    field RFU_Tsm2_i3 @0 {
       bits 1;
       access rw;
       reset 1'h0;
    }
  }
  register TxDqDlyTg0_r3_p0 @'h3c0 {
    field TxDqDlyTg0_r3_p0 @0 {
       bits 9;
       access rw;
       reset 9'h10;
    }
  }
  register TxDqDlyTg1_r3_p0 @'h3c1 {
    field TxDqDlyTg1_r3_p0 @0 {
       bits 9;
       access rw;
       reset 9'h10;
    }
  }
  register TxDqDlyTg2_r3_p0 @'h3c2 {
    field TxDqDlyTg2_r3_p0 @0 {
       bits 9;
       access rw;
       reset 9'h10;
    }
  }
  register TxDqDlyTg3_r3_p0 @'h3c3 {
    field TxDqDlyTg3_r3_p0 @0 {
       bits 9;
       access rw;
       reset 9'h10;
    }
  }
  register VrefDAC1_r4 @'h430 {
    field VrefDAC1_r4 @0 {
       bits 7;
       access rw;
       reset 7'h0;
    }
  }
  register TrainingCntr_r4 @'h432 {
    field RFU_TrainingCntr_r4 @0 {
       bits 16;
       access rw;
       reset 16'h0;
    }
  }
  register VrefDAC0_r4 @'h440 {
    field VrefDAC0_r4 @0 {
       bits 7;
       access rw;
       reset 7'h0;
    }
  }
  register TrainingIncDecDtsmEn_r4 @'h462 {
    field TrainingIncDecDtsmEn_r4 @0 {
       bits 9;
       access rw;
       reset 9'h0;
    }
  }
  register RxPBDlyTg0_r4 @'h468 {
    field RxPBDlyTg0_r4 @0 {
       bits 7;
       access rw;
       reset 7'h0;
    }
  }
  register RxPBDlyTg1_r4 @'h469 {
    field RxPBDlyTg1_r4 @0 {
       bits 7;
       access rw;
       reset 7'h0;
    }
  }
  register RxPBDlyTg2_r4 @'h46a {
    field RxPBDlyTg2_r4 @0 {
       bits 7;
       access rw;
       reset 7'h0;
    }
  }
  register RxPBDlyTg3_r4 @'h46b {
    field RxPBDlyTg3_r4 @0 {
       bits 7;
       access rw;
       reset 7'h0;
    }
  }
  register Tsm0_i4 @'h4b2 {
    field RFU_Tsm0_i4 @0 {
       bits 14;
       access rw;
       reset 14'h0;
    }
  }
  register Tsm1_i4 @'h4b3 {
    field RFU_Tsm1_i4 @0 {
       bits 16;
       access ro;
       reset 16'h0;
    }
  }
  register Tsm2_i4 @'h4b4 {
    field RFU_Tsm2_i4 @0 {
       bits 1;
       access rw;
       reset 1'h0;
    }
  }
  register TxDqDlyTg0_r4_p0 @'h4c0 {
    field TxDqDlyTg0_r4_p0 @0 {
       bits 9;
       access rw;
       reset 9'h10;
    }
  }
  register TxDqDlyTg1_r4_p0 @'h4c1 {
    field TxDqDlyTg1_r4_p0 @0 {
       bits 9;
       access rw;
       reset 9'h10;
    }
  }
  register TxDqDlyTg2_r4_p0 @'h4c2 {
    field TxDqDlyTg2_r4_p0 @0 {
       bits 9;
       access rw;
       reset 9'h10;
    }
  }
  register TxDqDlyTg3_r4_p0 @'h4c3 {
    field TxDqDlyTg3_r4_p0 @0 {
       bits 9;
       access rw;
       reset 9'h10;
    }
  }
  register VrefDAC1_r5 @'h530 {
    field VrefDAC1_r5 @0 {
       bits 7;
       access rw;
       reset 7'h0;
    }
  }
  register TrainingCntr_r5 @'h532 {
    field RFU_TrainingCntr_r5 @0 {
       bits 16;
       access rw;
       reset 16'h0;
    }
  }
  register VrefDAC0_r5 @'h540 {
    field VrefDAC0_r5 @0 {
       bits 7;
       access rw;
       reset 7'h0;
    }
  }
  register TrainingIncDecDtsmEn_r5 @'h562 {
    field TrainingIncDecDtsmEn_r5 @0 {
       bits 9;
       access rw;
       reset 9'h0;
    }
  }
  register RxPBDlyTg0_r5 @'h568 {
    field RxPBDlyTg0_r5 @0 {
       bits 7;
       access rw;
       reset 7'h0;
    }
  }
  register RxPBDlyTg1_r5 @'h569 {
    field RxPBDlyTg1_r5 @0 {
       bits 7;
       access rw;
       reset 7'h0;
    }
  }
  register RxPBDlyTg2_r5 @'h56a {
    field RxPBDlyTg2_r5 @0 {
       bits 7;
       access rw;
       reset 7'h0;
    }
  }
  register RxPBDlyTg3_r5 @'h56b {
    field RxPBDlyTg3_r5 @0 {
       bits 7;
       access rw;
       reset 7'h0;
    }
  }
  register Tsm0_i5 @'h5b2 {
    field RFU_Tsm0_i5 @0 {
       bits 14;
       access rw;
       reset 14'h0;
    }
  }
  register Tsm1_i5 @'h5b3 {
    field RFU_Tsm1_i5 @0 {
       bits 16;
       access ro;
       reset 16'h0;
    }
  }
  register Tsm2_i5 @'h5b4 {
    field RFU_Tsm2_i5 @0 {
       bits 1;
       access rw;
       reset 1'h0;
    }
  }
  register TxDqDlyTg0_r5_p0 @'h5c0 {
    field TxDqDlyTg0_r5_p0 @0 {
       bits 9;
       access rw;
       reset 9'h10;
    }
  }
  register TxDqDlyTg1_r5_p0 @'h5c1 {
    field TxDqDlyTg1_r5_p0 @0 {
       bits 9;
       access rw;
       reset 9'h10;
    }
  }
  register TxDqDlyTg2_r5_p0 @'h5c2 {
    field TxDqDlyTg2_r5_p0 @0 {
       bits 9;
       access rw;
       reset 9'h10;
    }
  }
  register TxDqDlyTg3_r5_p0 @'h5c3 {
    field TxDqDlyTg3_r5_p0 @0 {
       bits 9;
       access rw;
       reset 9'h10;
    }
  }
  register VrefDAC1_r6 @'h630 {
    field VrefDAC1_r6 @0 {
       bits 7;
       access rw;
       reset 7'h0;
    }
  }
  register TrainingCntr_r6 @'h632 {
    field RFU_TrainingCntr_r6 @0 {
       bits 16;
       access rw;
       reset 16'h0;
    }
  }
  register VrefDAC0_r6 @'h640 {
    field VrefDAC0_r6 @0 {
       bits 7;
       access rw;
       reset 7'h0;
    }
  }
  register TrainingIncDecDtsmEn_r6 @'h662 {
    field TrainingIncDecDtsmEn_r6 @0 {
       bits 9;
       access rw;
       reset 9'h0;
    }
  }
  register RxPBDlyTg0_r6 @'h668 {
    field RxPBDlyTg0_r6 @0 {
       bits 7;
       access rw;
       reset 7'h0;
    }
  }
  register RxPBDlyTg1_r6 @'h669 {
    field RxPBDlyTg1_r6 @0 {
       bits 7;
       access rw;
       reset 7'h0;
    }
  }
  register RxPBDlyTg2_r6 @'h66a {
    field RxPBDlyTg2_r6 @0 {
       bits 7;
       access rw;
       reset 7'h0;
    }
  }
  register RxPBDlyTg3_r6 @'h66b {
    field RxPBDlyTg3_r6 @0 {
       bits 7;
       access rw;
       reset 7'h0;
    }
  }
  register Tsm0_i6 @'h6b2 {
    field RFU_Tsm0_i6 @0 {
       bits 14;
       access rw;
       reset 14'h0;
    }
  }
  register Tsm1_i6 @'h6b3 {
    field RFU_Tsm1_i6 @0 {
       bits 16;
       access ro;
       reset 16'h0;
    }
  }
  register Tsm2_i6 @'h6b4 {
    field RFU_Tsm2_i6 @0 {
       bits 1;
       access rw;
       reset 1'h0;
    }
  }
  register TxDqDlyTg0_r6_p0 @'h6c0 {
    field TxDqDlyTg0_r6_p0 @0 {
       bits 9;
       access rw;
       reset 9'h10;
    }
  }
  register TxDqDlyTg1_r6_p0 @'h6c1 {
    field TxDqDlyTg1_r6_p0 @0 {
       bits 9;
       access rw;
       reset 9'h10;
    }
  }
  register TxDqDlyTg2_r6_p0 @'h6c2 {
    field TxDqDlyTg2_r6_p0 @0 {
       bits 9;
       access rw;
       reset 9'h10;
    }
  }
  register TxDqDlyTg3_r6_p0 @'h6c3 {
    field TxDqDlyTg3_r6_p0 @0 {
       bits 9;
       access rw;
       reset 9'h10;
    }
  }
  register VrefDAC1_r7 @'h730 {
    field VrefDAC1_r7 @0 {
       bits 7;
       access rw;
       reset 7'h0;
    }
  }
  register TrainingCntr_r7 @'h732 {
    field RFU_TrainingCntr_r7 @0 {
       bits 16;
       access rw;
       reset 16'h0;
    }
  }
  register VrefDAC0_r7 @'h740 {
    field VrefDAC0_r7 @0 {
       bits 7;
       access rw;
       reset 7'h0;
    }
  }
  register TrainingIncDecDtsmEn_r7 @'h762 {
    field TrainingIncDecDtsmEn_r7 @0 {
       bits 9;
       access rw;
       reset 9'h0;
    }
  }
  register RxPBDlyTg0_r7 @'h768 {
    field RxPBDlyTg0_r7 @0 {
       bits 7;
       access rw;
       reset 7'h0;
    }
  }
  register RxPBDlyTg1_r7 @'h769 {
    field RxPBDlyTg1_r7 @0 {
       bits 7;
       access rw;
       reset 7'h0;
    }
  }
  register RxPBDlyTg2_r7 @'h76a {
    field RxPBDlyTg2_r7 @0 {
       bits 7;
       access rw;
       reset 7'h0;
    }
  }
  register RxPBDlyTg3_r7 @'h76b {
    field RxPBDlyTg3_r7 @0 {
       bits 7;
       access rw;
       reset 7'h0;
    }
  }
  register Tsm0_i7 @'h7b2 {
    field RFU_Tsm0_i7 @0 {
       bits 14;
       access rw;
       reset 14'h0;
    }
  }
  register Tsm1_i7 @'h7b3 {
    field RFU_Tsm1_i7 @0 {
       bits 16;
       access ro;
       reset 16'h0;
    }
  }
  register Tsm2_i7 @'h7b4 {
    field RFU_Tsm2_i7 @0 {
       bits 1;
       access rw;
       reset 1'h0;
    }
  }
  register TxDqDlyTg0_r7_p0 @'h7c0 {
    field TxDqDlyTg0_r7_p0 @0 {
       bits 9;
       access rw;
       reset 9'h10;
    }
  }
  register TxDqDlyTg1_r7_p0 @'h7c1 {
    field TxDqDlyTg1_r7_p0 @0 {
       bits 9;
       access rw;
       reset 9'h10;
    }
  }
  register TxDqDlyTg2_r7_p0 @'h7c2 {
    field TxDqDlyTg2_r7_p0 @0 {
       bits 9;
       access rw;
       reset 9'h10;
    }
  }
  register TxDqDlyTg3_r7_p0 @'h7c3 {
    field TxDqDlyTg3_r7_p0 @0 {
       bits 9;
       access rw;
       reset 9'h10;
    }
  }
  register VrefDAC1_r8 @'h830 {
    field VrefDAC1_r8 @0 {
       bits 7;
       access rw;
       reset 7'h0;
    }
  }
  register TrainingCntr_r8 @'h832 {
    field RFU_TrainingCntr_r8 @0 {
       bits 16;
       access rw;
       reset 16'h0;
    }
  }
  register VrefDAC0_r8 @'h840 {
    field VrefDAC0_r8 @0 {
       bits 7;
       access rw;
       reset 7'h0;
    }
  }
  register TrainingIncDecDtsmEn_r8 @'h862 {
    field TrainingIncDecDtsmEn_r8 @0 {
       bits 9;
       access rw;
       reset 9'h0;
    }
  }
  register RxPBDlyTg0_r8 @'h868 {
    field RxPBDlyTg0_r8 @0 {
       bits 7;
       access rw;
       reset 7'h0;
    }
  }
  register RxPBDlyTg1_r8 @'h869 {
    field RxPBDlyTg1_r8 @0 {
       bits 7;
       access rw;
       reset 7'h0;
    }
  }
  register RxPBDlyTg2_r8 @'h86a {
    field RxPBDlyTg2_r8 @0 {
       bits 7;
       access rw;
       reset 7'h0;
    }
  }
  register RxPBDlyTg3_r8 @'h86b {
    field RxPBDlyTg3_r8 @0 {
       bits 7;
       access rw;
       reset 7'h0;
    }
  }
  register Tsm0_i8 @'h8b2 {
    field RFU_Tsm0_i8 @0 {
       bits 14;
       access rw;
       reset 14'h0;
    }
  }
  register Tsm1_i8 @'h8b3 {
    field RFU_Tsm1_i8 @0 {
       bits 16;
       access ro;
       reset 16'h0;
    }
  }
  register Tsm2_i8 @'h8b4 {
    field RFU_Tsm2_i8 @0 {
       bits 1;
       access rw;
       reset 1'h0;
    }
  }
  register TxDqDlyTg0_r8_p0 @'h8c0 {
    field TxDqDlyTg0_r8_p0 @0 {
       bits 9;
       access rw;
       reset 9'h10;
    }
  }
  register TxDqDlyTg1_r8_p0 @'h8c1 {
    field TxDqDlyTg1_r8_p0 @0 {
       bits 9;
       access rw;
       reset 9'h10;
    }
  }
  register TxDqDlyTg2_r8_p0 @'h8c2 {
    field TxDqDlyTg2_r8_p0 @0 {
       bits 9;
       access rw;
       reset 9'h10;
    }
  }
  register TxDqDlyTg3_r8_p0 @'h8c3 {
    field TxDqDlyTg3_r8_p0 @0 {
       bits 9;
       access rw;
       reset 9'h10;
    }
  }
  register UseDqsEnReplica_p1 @'h100003 {
    field UseDqsEnReplica_p1 @0 {
       bits 1;
       access rw;
       reset 1'h0;
    }
  }
  register DFIMRL_p1 @'h100020 {
    field DFIMRL_p1 @0 {
       bits 5;
       access rw;
       reset 5'h6;
    }
  }
  register TxImpedanceCtrl0_b0_p1 @'h100041 {
    field DrvStrenDqP @0 {
       bits 6;
       access rw;
       reset 6'h3f;
    }
    field DrvStrenDqN @6 {
       bits 6;
       access rw;
       reset 6'h3f;
    }
  }
  register DqDqsRcvCntrl_b0_p1 @'h100043 {
    field SelAnalogVref @0 {
       bits 1;
       access rw;
       reset 1'h0;
    }
    field ExtVrefRange @1 {
       bits 1;
       access rw;
       reset 1'h0;
    }
    field DfeCtrl @2 {
       bits 2;
       access rw;
       reset 2'h0;
    }
    field MajorModeDbyte @4 {
       bits 3;
       access rw;
       reset 3'h3;
    }
    field GainCurrAdj @7 {
       bits 5;
       access rw;
       reset 5'hb;
    }
    field Reserved @12 {
       bits 4;
    }
  }
  register TxEqualizationMode_p1 @'h100048 {
    field TxEqMode @0 {
       bits 2;
       access rw;
       reset 2'h0;
    }
  }
  register TxImpedanceCtrl1_b0_p1 @'h100049 {
    field DrvStrenFSDqP @0 {
       bits 6;
       access rw;
       reset 6'h3f;
    }
    field DrvStrenFSDqN @6 {
       bits 6;
       access rw;
       reset 6'h3f;
    }
  }
  register TxImpedanceCtrl2_b0_p1 @'h10004b {
    field DrvStrenEQHiDqP @0 {
       bits 6;
       access rw;
       reset 6'h0;
    }
    field DrvStrenEQLoDqN @6 {
       bits 6;
       access rw;
       reset 6'h0;
    }
  }
  register DqDqsRcvCntrl2_p1 @'h10004c {
    field EnRxAgressivePDR @0 {
       bits 1;
       access rw;
       reset 1'h0;
    }
  }
  register TxOdtDrvStren_b0_p1 @'h10004d {
    field ODTStrenP @0 {
       bits 6;
       access rw;
       reset 6'h0;
    }
    field ODTStrenN @6 {
       bits 6;
       access rw;
       reset 6'h0;
    }
  }
  register TxSlewRate_b0_p1 @'h10005f {
    field TxPreP @0 {
       bits 4;
       access rw;
       reset 4'hf;
    }
    field TxPreN @4 {
       bits 4;
       access rw;
       reset 4'hf;
    }
    field TxPreDrvMode @8 {
       bits 3;
       access rw;
       reset 3'h7;
    }
  }
  register RxEnDlyTg0_u0_p1 @'h100080 {
    field RxEnDlyTg0_u0_p1 @0 {
       bits 11;
       access rw;
       reset 11'h100;
    }
  }
  register RxEnDlyTg1_u0_p1 @'h100081 {
    field RxEnDlyTg1_u0_p1 @0 {
       bits 11;
       access rw;
       reset 11'h100;
    }
  }
  register RxEnDlyTg2_u0_p1 @'h100082 {
    field RxEnDlyTg2_u0_p1 @0 {
       bits 11;
       access rw;
       reset 11'h100;
    }
  }
  register RxEnDlyTg3_u0_p1 @'h100083 {
    field RxEnDlyTg3_u0_p1 @0 {
       bits 11;
       access rw;
       reset 11'h100;
    }
  }
  register RxClkDlyTg0_u0_p1 @'h10008c {
    field RxClkDlyTg0_u0_p1 @0 {
       bits 6;
       access rw;
       reset 6'h10;
    }
  }
  register RxClkDlyTg1_u0_p1 @'h10008d {
    field RxClkDlyTg1_u0_p1 @0 {
       bits 6;
       access rw;
       reset 6'h10;
    }
  }
  register RxClkDlyTg2_u0_p1 @'h10008e {
    field RxClkDlyTg2_u0_p1 @0 {
       bits 6;
       access rw;
       reset 6'h10;
    }
  }
  register RxClkDlyTg3_u0_p1 @'h10008f {
    field RxClkDlyTg3_u0_p1 @0 {
       bits 6;
       access rw;
       reset 6'h10;
    }
  }
  register RxClkcDlyTg0_u0_p1 @'h100090 {
    field RxClkcDlyTg0_u0_p1 @0 {
       bits 6;
       access rw;
       reset 6'h10;
    }
  }
  register RxClkcDlyTg1_u0_p1 @'h100091 {
    field RxClkcDlyTg1_u0_p1 @0 {
       bits 6;
       access rw;
       reset 6'h10;
    }
  }
  register RxClkcDlyTg2_u0_p1 @'h100092 {
    field RxClkcDlyTg2_u0_p1 @0 {
       bits 6;
       access rw;
       reset 6'h10;
    }
  }
  register RxClkcDlyTg3_u0_p1 @'h100093 {
    field RxClkcDlyTg3_u0_p1 @0 {
       bits 6;
       access rw;
       reset 6'h10;
    }
  }
  register PptDqsCntInvTrnTg0_p1 @'h1000ae {
    field PptDqsCntInvTrnTg0_p1 @0 {
       bits 16;
       access rw;
       reset 16'h0;
    }
  }
  register PptDqsCntInvTrnTg1_p1 @'h1000af {
    field PptDqsCntInvTrnTg1_p1 @0 {
       bits 16;
       access rw;
       reset 16'h0;
    }
  }
  register TxDqDlyTg0_r0_p1 @'h1000c0 {
    field TxDqDlyTg0_r0_p1 @0 {
       bits 9;
       access rw;
       reset 9'h10;
    }
  }
  register TxDqDlyTg1_r0_p1 @'h1000c1 {
    field TxDqDlyTg1_r0_p1 @0 {
       bits 9;
       access rw;
       reset 9'h10;
    }
  }
  register TxDqDlyTg2_r0_p1 @'h1000c2 {
    field TxDqDlyTg2_r0_p1 @0 {
       bits 9;
       access rw;
       reset 9'h10;
    }
  }
  register TxDqDlyTg3_r0_p1 @'h1000c3 {
    field TxDqDlyTg3_r0_p1 @0 {
       bits 9;
       access rw;
       reset 9'h10;
    }
  }
  register TxDqsDlyTg0_u0_p1 @'h1000d0 {
    field TxDqsDlyTg0_u0_p1 @0 {
       bits 10;
       access rw;
       reset 10'h100;
    }
  }
  register TxDqsDlyTg1_u0_p1 @'h1000d1 {
    field TxDqsDlyTg1_u0_p1 @0 {
       bits 10;
       access rw;
       reset 10'h100;
    }
  }
  register TxDqsDlyTg2_u0_p1 @'h1000d2 {
    field TxDqsDlyTg2_u0_p1 @0 {
       bits 10;
       access rw;
       reset 10'h100;
    }
  }
  register TxDqsDlyTg3_u0_p1 @'h1000d3 {
    field TxDqsDlyTg3_u0_p1 @0 {
       bits 10;
       access rw;
       reset 10'h100;
    }
  }
  register TxImpedanceCtrl0_b1_p1 @'h100141 {
    field DrvStrenDqP @0 {
       bits 6;
       access rw;
       reset 6'h3f;
    }
    field DrvStrenDqN @6 {
       bits 6;
       access rw;
       reset 6'h3f;
    }
  }
  register DqDqsRcvCntrl_b1_p1 @'h100143 {
    field SelAnalogVref @0 {
       bits 1;
       access rw;
       reset 1'h0;
    }
    field ExtVrefRange @1 {
       bits 1;
       access rw;
       reset 1'h0;
    }
    field DfeCtrl @2 {
       bits 2;
       access rw;
       reset 2'h0;
    }
    field MajorModeDbyte @4 {
       bits 3;
       access rw;
       reset 3'h3;
    }
    field GainCurrAdj @7 {
       bits 5;
       access rw;
       reset 5'hb;
    }
    field Reserved @12 {
       bits 4;
    }
  }
  register TxImpedanceCtrl1_b1_p1 @'h100149 {
    field DrvStrenFSDqP @0 {
       bits 6;
       access rw;
       reset 6'h3f;
    }
    field DrvStrenFSDqN @6 {
       bits 6;
       access rw;
       reset 6'h3f;
    }
  }
  register TxImpedanceCtrl2_b1_p1 @'h10014b {
    field DrvStrenEQHiDqP @0 {
       bits 6;
       access rw;
       reset 6'h0;
    }
    field DrvStrenEQLoDqN @6 {
       bits 6;
       access rw;
       reset 6'h0;
    }
  }
  register TxOdtDrvStren_b1_p1 @'h10014d {
    field ODTStrenP @0 {
       bits 6;
       access rw;
       reset 6'h0;
    }
    field ODTStrenN @6 {
       bits 6;
       access rw;
       reset 6'h0;
    }
  }
  register TxSlewRate_b1_p1 @'h10015f {
    field TxPreP @0 {
       bits 4;
       access rw;
       reset 4'hf;
    }
    field TxPreN @4 {
       bits 4;
       access rw;
       reset 4'hf;
    }
    field TxPreDrvMode @8 {
       bits 3;
       access rw;
       reset 3'h7;
    }
  }
  register RxEnDlyTg0_u1_p1 @'h100180 {
    field RxEnDlyTg0_u1_p1 @0 {
       bits 11;
       access rw;
       reset 11'h100;
    }
  }
  register RxEnDlyTg1_u1_p1 @'h100181 {
    field RxEnDlyTg1_u1_p1 @0 {
       bits 11;
       access rw;
       reset 11'h100;
    }
  }
  register RxEnDlyTg2_u1_p1 @'h100182 {
    field RxEnDlyTg2_u1_p1 @0 {
       bits 11;
       access rw;
       reset 11'h100;
    }
  }
  register RxEnDlyTg3_u1_p1 @'h100183 {
    field RxEnDlyTg3_u1_p1 @0 {
       bits 11;
       access rw;
       reset 11'h100;
    }
  }
  register RxClkDlyTg0_u1_p1 @'h10018c {
    field RxClkDlyTg0_u1_p1 @0 {
       bits 6;
       access rw;
       reset 6'h10;
    }
  }
  register RxClkDlyTg1_u1_p1 @'h10018d {
    field RxClkDlyTg1_u1_p1 @0 {
       bits 6;
       access rw;
       reset 6'h10;
    }
  }
  register RxClkDlyTg2_u1_p1 @'h10018e {
    field RxClkDlyTg2_u1_p1 @0 {
       bits 6;
       access rw;
       reset 6'h10;
    }
  }
  register RxClkDlyTg3_u1_p1 @'h10018f {
    field RxClkDlyTg3_u1_p1 @0 {
       bits 6;
       access rw;
       reset 6'h10;
    }
  }
  register RxClkcDlyTg0_u1_p1 @'h100190 {
    field RxClkcDlyTg0_u1_p1 @0 {
       bits 6;
       access rw;
       reset 6'h10;
    }
  }
  register RxClkcDlyTg1_u1_p1 @'h100191 {
    field RxClkcDlyTg1_u1_p1 @0 {
       bits 6;
       access rw;
       reset 6'h10;
    }
  }
  register RxClkcDlyTg2_u1_p1 @'h100192 {
    field RxClkcDlyTg2_u1_p1 @0 {
       bits 6;
       access rw;
       reset 6'h10;
    }
  }
  register RxClkcDlyTg3_u1_p1 @'h100193 {
    field RxClkcDlyTg3_u1_p1 @0 {
       bits 6;
       access rw;
       reset 6'h10;
    }
  }
  register TxDqDlyTg0_r1_p1 @'h1001c0 {
    field TxDqDlyTg0_r1_p1 @0 {
       bits 9;
       access rw;
       reset 9'h10;
    }
  }
  register TxDqDlyTg1_r1_p1 @'h1001c1 {
    field TxDqDlyTg1_r1_p1 @0 {
       bits 9;
       access rw;
       reset 9'h10;
    }
  }
  register TxDqDlyTg2_r1_p1 @'h1001c2 {
    field TxDqDlyTg2_r1_p1 @0 {
       bits 9;
       access rw;
       reset 9'h10;
    }
  }
  register TxDqDlyTg3_r1_p1 @'h1001c3 {
    field TxDqDlyTg3_r1_p1 @0 {
       bits 9;
       access rw;
       reset 9'h10;
    }
  }
  register TxDqsDlyTg0_u1_p1 @'h1001d0 {
    field TxDqsDlyTg0_u1_p1 @0 {
       bits 10;
       access rw;
       reset 10'h100;
    }
  }
  register TxDqsDlyTg1_u1_p1 @'h1001d1 {
    field TxDqsDlyTg1_u1_p1 @0 {
       bits 10;
       access rw;
       reset 10'h100;
    }
  }
  register TxDqsDlyTg2_u1_p1 @'h1001d2 {
    field TxDqsDlyTg2_u1_p1 @0 {
       bits 10;
       access rw;
       reset 10'h100;
    }
  }
  register TxDqsDlyTg3_u1_p1 @'h1001d3 {
    field TxDqsDlyTg3_u1_p1 @0 {
       bits 10;
       access rw;
       reset 10'h100;
    }
  }
  register TxDqDlyTg0_r2_p1 @'h1002c0 {
    field TxDqDlyTg0_r2_p1 @0 {
       bits 9;
       access rw;
       reset 9'h10;
    }
  }
  register TxDqDlyTg1_r2_p1 @'h1002c1 {
    field TxDqDlyTg1_r2_p1 @0 {
       bits 9;
       access rw;
       reset 9'h10;
    }
  }
  register TxDqDlyTg2_r2_p1 @'h1002c2 {
    field TxDqDlyTg2_r2_p1 @0 {
       bits 9;
       access rw;
       reset 9'h10;
    }
  }
  register TxDqDlyTg3_r2_p1 @'h1002c3 {
    field TxDqDlyTg3_r2_p1 @0 {
       bits 9;
       access rw;
       reset 9'h10;
    }
  }
  register TxDqDlyTg0_r3_p1 @'h1003c0 {
    field TxDqDlyTg0_r3_p1 @0 {
       bits 9;
       access rw;
       reset 9'h10;
    }
  }
  register TxDqDlyTg1_r3_p1 @'h1003c1 {
    field TxDqDlyTg1_r3_p1 @0 {
       bits 9;
       access rw;
       reset 9'h10;
    }
  }
  register TxDqDlyTg2_r3_p1 @'h1003c2 {
    field TxDqDlyTg2_r3_p1 @0 {
       bits 9;
       access rw;
       reset 9'h10;
    }
  }
  register TxDqDlyTg3_r3_p1 @'h1003c3 {
    field TxDqDlyTg3_r3_p1 @0 {
       bits 9;
       access rw;
       reset 9'h10;
    }
  }
  register TxDqDlyTg0_r4_p1 @'h1004c0 {
    field TxDqDlyTg0_r4_p1 @0 {
       bits 9;
       access rw;
       reset 9'h10;
    }
  }
  register TxDqDlyTg1_r4_p1 @'h1004c1 {
    field TxDqDlyTg1_r4_p1 @0 {
       bits 9;
       access rw;
       reset 9'h10;
    }
  }
  register TxDqDlyTg2_r4_p1 @'h1004c2 {
    field TxDqDlyTg2_r4_p1 @0 {
       bits 9;
       access rw;
       reset 9'h10;
    }
  }
  register TxDqDlyTg3_r4_p1 @'h1004c3 {
    field TxDqDlyTg3_r4_p1 @0 {
       bits 9;
       access rw;
       reset 9'h10;
    }
  }
  register TxDqDlyTg0_r5_p1 @'h1005c0 {
    field TxDqDlyTg0_r5_p1 @0 {
       bits 9;
       access rw;
       reset 9'h10;
    }
  }
  register TxDqDlyTg1_r5_p1 @'h1005c1 {
    field TxDqDlyTg1_r5_p1 @0 {
       bits 9;
       access rw;
       reset 9'h10;
    }
  }
  register TxDqDlyTg2_r5_p1 @'h1005c2 {
    field TxDqDlyTg2_r5_p1 @0 {
       bits 9;
       access rw;
       reset 9'h10;
    }
  }
  register TxDqDlyTg3_r5_p1 @'h1005c3 {
    field TxDqDlyTg3_r5_p1 @0 {
       bits 9;
       access rw;
       reset 9'h10;
    }
  }
  register TxDqDlyTg0_r6_p1 @'h1006c0 {
    field TxDqDlyTg0_r6_p1 @0 {
       bits 9;
       access rw;
       reset 9'h10;
    }
  }
  register TxDqDlyTg1_r6_p1 @'h1006c1 {
    field TxDqDlyTg1_r6_p1 @0 {
       bits 9;
       access rw;
       reset 9'h10;
    }
  }
  register TxDqDlyTg2_r6_p1 @'h1006c2 {
    field TxDqDlyTg2_r6_p1 @0 {
       bits 9;
       access rw;
       reset 9'h10;
    }
  }
  register TxDqDlyTg3_r6_p1 @'h1006c3 {
    field TxDqDlyTg3_r6_p1 @0 {
       bits 9;
       access rw;
       reset 9'h10;
    }
  }
  register TxDqDlyTg0_r7_p1 @'h1007c0 {
    field TxDqDlyTg0_r7_p1 @0 {
       bits 9;
       access rw;
       reset 9'h10;
    }
  }
  register TxDqDlyTg1_r7_p1 @'h1007c1 {
    field TxDqDlyTg1_r7_p1 @0 {
       bits 9;
       access rw;
       reset 9'h10;
    }
  }
  register TxDqDlyTg2_r7_p1 @'h1007c2 {
    field TxDqDlyTg2_r7_p1 @0 {
       bits 9;
       access rw;
       reset 9'h10;
    }
  }
  register TxDqDlyTg3_r7_p1 @'h1007c3 {
    field TxDqDlyTg3_r7_p1 @0 {
       bits 9;
       access rw;
       reset 9'h10;
    }
  }
  register TxDqDlyTg0_r8_p1 @'h1008c0 {
    field TxDqDlyTg0_r8_p1 @0 {
       bits 9;
       access rw;
       reset 9'h10;
    }
  }
  register TxDqDlyTg1_r8_p1 @'h1008c1 {
    field TxDqDlyTg1_r8_p1 @0 {
       bits 9;
       access rw;
       reset 9'h10;
    }
  }
  register TxDqDlyTg2_r8_p1 @'h1008c2 {
    field TxDqDlyTg2_r8_p1 @0 {
       bits 9;
       access rw;
       reset 9'h10;
    }
  }
  register TxDqDlyTg3_r8_p1 @'h1008c3 {
    field TxDqDlyTg3_r8_p1 @0 {
       bits 9;
       access rw;
       reset 9'h10;
    }
  }
  register UseDqsEnReplica_p2 @'h200003 {
    field UseDqsEnReplica_p2 @0 {
       bits 1;
       access rw;
       reset 1'h0;
    }
  }
  register DFIMRL_p2 @'h200020 {
    field DFIMRL_p2 @0 {
       bits 5;
       access rw;
       reset 5'h6;
    }
  }
  register TxImpedanceCtrl0_b0_p2 @'h200041 {
    field DrvStrenDqP @0 {
       bits 6;
       access rw;
       reset 6'h3f;
    }
    field DrvStrenDqN @6 {
       bits 6;
       access rw;
       reset 6'h3f;
    }
  }
  register DqDqsRcvCntrl_b0_p2 @'h200043 {
    field SelAnalogVref @0 {
       bits 1;
       access rw;
       reset 1'h0;
    }
    field ExtVrefRange @1 {
       bits 1;
       access rw;
       reset 1'h0;
    }
    field DfeCtrl @2 {
       bits 2;
       access rw;
       reset 2'h0;
    }
    field MajorModeDbyte @4 {
       bits 3;
       access rw;
       reset 3'h3;
    }
    field GainCurrAdj @7 {
       bits 5;
       access rw;
       reset 5'hb;
    }
    field Reserved @12 {
       bits 4;
    }
  }
  register TxEqualizationMode_p2 @'h200048 {
    field TxEqMode @0 {
       bits 2;
       access rw;
       reset 2'h0;
    }
  }
  register TxImpedanceCtrl1_b0_p2 @'h200049 {
    field DrvStrenFSDqP @0 {
       bits 6;
       access rw;
       reset 6'h3f;
    }
    field DrvStrenFSDqN @6 {
       bits 6;
       access rw;
       reset 6'h3f;
    }
  }
  register TxImpedanceCtrl2_b0_p2 @'h20004b {
    field DrvStrenEQHiDqP @0 {
       bits 6;
       access rw;
       reset 6'h0;
    }
    field DrvStrenEQLoDqN @6 {
       bits 6;
       access rw;
       reset 6'h0;
    }
  }
  register DqDqsRcvCntrl2_p2 @'h20004c {
    field EnRxAgressivePDR @0 {
       bits 1;
       access rw;
       reset 1'h0;
    }
  }
  register TxOdtDrvStren_b0_p2 @'h20004d {
    field ODTStrenP @0 {
       bits 6;
       access rw;
       reset 6'h0;
    }
    field ODTStrenN @6 {
       bits 6;
       access rw;
       reset 6'h0;
    }
  }
  register TxSlewRate_b0_p2 @'h20005f {
    field TxPreP @0 {
       bits 4;
       access rw;
       reset 4'hf;
    }
    field TxPreN @4 {
       bits 4;
       access rw;
       reset 4'hf;
    }
    field TxPreDrvMode @8 {
       bits 3;
       access rw;
       reset 3'h7;
    }
  }
  register RxEnDlyTg0_u0_p2 @'h200080 {
    field RxEnDlyTg0_u0_p2 @0 {
       bits 11;
       access rw;
       reset 11'h100;
    }
  }
  register RxEnDlyTg1_u0_p2 @'h200081 {
    field RxEnDlyTg1_u0_p2 @0 {
       bits 11;
       access rw;
       reset 11'h100;
    }
  }
  register RxEnDlyTg2_u0_p2 @'h200082 {
    field RxEnDlyTg2_u0_p2 @0 {
       bits 11;
       access rw;
       reset 11'h100;
    }
  }
  register RxEnDlyTg3_u0_p2 @'h200083 {
    field RxEnDlyTg3_u0_p2 @0 {
       bits 11;
       access rw;
       reset 11'h100;
    }
  }
  register RxClkDlyTg0_u0_p2 @'h20008c {
    field RxClkDlyTg0_u0_p2 @0 {
       bits 6;
       access rw;
       reset 6'h10;
    }
  }
  register RxClkDlyTg1_u0_p2 @'h20008d {
    field RxClkDlyTg1_u0_p2 @0 {
       bits 6;
       access rw;
       reset 6'h10;
    }
  }
  register RxClkDlyTg2_u0_p2 @'h20008e {
    field RxClkDlyTg2_u0_p2 @0 {
       bits 6;
       access rw;
       reset 6'h10;
    }
  }
  register RxClkDlyTg3_u0_p2 @'h20008f {
    field RxClkDlyTg3_u0_p2 @0 {
       bits 6;
       access rw;
       reset 6'h10;
    }
  }
  register RxClkcDlyTg0_u0_p2 @'h200090 {
    field RxClkcDlyTg0_u0_p2 @0 {
       bits 6;
       access rw;
       reset 6'h10;
    }
  }
  register RxClkcDlyTg1_u0_p2 @'h200091 {
    field RxClkcDlyTg1_u0_p2 @0 {
       bits 6;
       access rw;
       reset 6'h10;
    }
  }
  register RxClkcDlyTg2_u0_p2 @'h200092 {
    field RxClkcDlyTg2_u0_p2 @0 {
       bits 6;
       access rw;
       reset 6'h10;
    }
  }
  register RxClkcDlyTg3_u0_p2 @'h200093 {
    field RxClkcDlyTg3_u0_p2 @0 {
       bits 6;
       access rw;
       reset 6'h10;
    }
  }
  register PptDqsCntInvTrnTg0_p2 @'h2000ae {
    field PptDqsCntInvTrnTg0_p2 @0 {
       bits 16;
       access rw;
       reset 16'h0;
    }
  }
  register PptDqsCntInvTrnTg1_p2 @'h2000af {
    field PptDqsCntInvTrnTg1_p2 @0 {
       bits 16;
       access rw;
       reset 16'h0;
    }
  }
  register TxDqDlyTg0_r0_p2 @'h2000c0 {
    field TxDqDlyTg0_r0_p2 @0 {
       bits 9;
       access rw;
       reset 9'h10;
    }
  }
  register TxDqDlyTg1_r0_p2 @'h2000c1 {
    field TxDqDlyTg1_r0_p2 @0 {
       bits 9;
       access rw;
       reset 9'h10;
    }
  }
  register TxDqDlyTg2_r0_p2 @'h2000c2 {
    field TxDqDlyTg2_r0_p2 @0 {
       bits 9;
       access rw;
       reset 9'h10;
    }
  }
  register TxDqDlyTg3_r0_p2 @'h2000c3 {
    field TxDqDlyTg3_r0_p2 @0 {
       bits 9;
       access rw;
       reset 9'h10;
    }
  }
  register TxDqsDlyTg0_u0_p2 @'h2000d0 {
    field TxDqsDlyTg0_u0_p2 @0 {
       bits 10;
       access rw;
       reset 10'h100;
    }
  }
  register TxDqsDlyTg1_u0_p2 @'h2000d1 {
    field TxDqsDlyTg1_u0_p2 @0 {
       bits 10;
       access rw;
       reset 10'h100;
    }
  }
  register TxDqsDlyTg2_u0_p2 @'h2000d2 {
    field TxDqsDlyTg2_u0_p2 @0 {
       bits 10;
       access rw;
       reset 10'h100;
    }
  }
  register TxDqsDlyTg3_u0_p2 @'h2000d3 {
    field TxDqsDlyTg3_u0_p2 @0 {
       bits 10;
       access rw;
       reset 10'h100;
    }
  }
  register TxImpedanceCtrl0_b1_p2 @'h200141 {
    field DrvStrenDqP @0 {
       bits 6;
       access rw;
       reset 6'h3f;
    }
    field DrvStrenDqN @6 {
       bits 6;
       access rw;
       reset 6'h3f;
    }
  }
  register DqDqsRcvCntrl_b1_p2 @'h200143 {
    field SelAnalogVref @0 {
       bits 1;
       access rw;
       reset 1'h0;
    }
    field ExtVrefRange @1 {
       bits 1;
       access rw;
       reset 1'h0;
    }
    field DfeCtrl @2 {
       bits 2;
       access rw;
       reset 2'h0;
    }
    field MajorModeDbyte @4 {
       bits 3;
       access rw;
       reset 3'h3;
    }
    field GainCurrAdj @7 {
       bits 5;
       access rw;
       reset 5'hb;
    }
    field Reserved @12 {
       bits 4;
    }
  }
  register TxImpedanceCtrl1_b1_p2 @'h200149 {
    field DrvStrenFSDqP @0 {
       bits 6;
       access rw;
       reset 6'h3f;
    }
    field DrvStrenFSDqN @6 {
       bits 6;
       access rw;
       reset 6'h3f;
    }
  }
  register TxImpedanceCtrl2_b1_p2 @'h20014b {
    field DrvStrenEQHiDqP @0 {
       bits 6;
       access rw;
       reset 6'h0;
    }
    field DrvStrenEQLoDqN @6 {
       bits 6;
       access rw;
       reset 6'h0;
    }
  }
  register TxOdtDrvStren_b1_p2 @'h20014d {
    field ODTStrenP @0 {
       bits 6;
       access rw;
       reset 6'h0;
    }
    field ODTStrenN @6 {
       bits 6;
       access rw;
       reset 6'h0;
    }
  }
  register TxSlewRate_b1_p2 @'h20015f {
    field TxPreP @0 {
       bits 4;
       access rw;
       reset 4'hf;
    }
    field TxPreN @4 {
       bits 4;
       access rw;
       reset 4'hf;
    }
    field TxPreDrvMode @8 {
       bits 3;
       access rw;
       reset 3'h7;
    }
  }
  register RxEnDlyTg0_u1_p2 @'h200180 {
    field RxEnDlyTg0_u1_p2 @0 {
       bits 11;
       access rw;
       reset 11'h100;
    }
  }
  register RxEnDlyTg1_u1_p2 @'h200181 {
    field RxEnDlyTg1_u1_p2 @0 {
       bits 11;
       access rw;
       reset 11'h100;
    }
  }
  register RxEnDlyTg2_u1_p2 @'h200182 {
    field RxEnDlyTg2_u1_p2 @0 {
       bits 11;
       access rw;
       reset 11'h100;
    }
  }
  register RxEnDlyTg3_u1_p2 @'h200183 {
    field RxEnDlyTg3_u1_p2 @0 {
       bits 11;
       access rw;
       reset 11'h100;
    }
  }
  register RxClkDlyTg0_u1_p2 @'h20018c {
    field RxClkDlyTg0_u1_p2 @0 {
       bits 6;
       access rw;
       reset 6'h10;
    }
  }
  register RxClkDlyTg1_u1_p2 @'h20018d {
    field RxClkDlyTg1_u1_p2 @0 {
       bits 6;
       access rw;
       reset 6'h10;
    }
  }
  register RxClkDlyTg2_u1_p2 @'h20018e {
    field RxClkDlyTg2_u1_p2 @0 {
       bits 6;
       access rw;
       reset 6'h10;
    }
  }
  register RxClkDlyTg3_u1_p2 @'h20018f {
    field RxClkDlyTg3_u1_p2 @0 {
       bits 6;
       access rw;
       reset 6'h10;
    }
  }
  register RxClkcDlyTg0_u1_p2 @'h200190 {
    field RxClkcDlyTg0_u1_p2 @0 {
       bits 6;
       access rw;
       reset 6'h10;
    }
  }
  register RxClkcDlyTg1_u1_p2 @'h200191 {
    field RxClkcDlyTg1_u1_p2 @0 {
       bits 6;
       access rw;
       reset 6'h10;
    }
  }
  register RxClkcDlyTg2_u1_p2 @'h200192 {
    field RxClkcDlyTg2_u1_p2 @0 {
       bits 6;
       access rw;
       reset 6'h10;
    }
  }
  register RxClkcDlyTg3_u1_p2 @'h200193 {
    field RxClkcDlyTg3_u1_p2 @0 {
       bits 6;
       access rw;
       reset 6'h10;
    }
  }
  register TxDqDlyTg0_r1_p2 @'h2001c0 {
    field TxDqDlyTg0_r1_p2 @0 {
       bits 9;
       access rw;
       reset 9'h10;
    }
  }
  register TxDqDlyTg1_r1_p2 @'h2001c1 {
    field TxDqDlyTg1_r1_p2 @0 {
       bits 9;
       access rw;
       reset 9'h10;
    }
  }
  register TxDqDlyTg2_r1_p2 @'h2001c2 {
    field TxDqDlyTg2_r1_p2 @0 {
       bits 9;
       access rw;
       reset 9'h10;
    }
  }
  register TxDqDlyTg3_r1_p2 @'h2001c3 {
    field TxDqDlyTg3_r1_p2 @0 {
       bits 9;
       access rw;
       reset 9'h10;
    }
  }
  register TxDqsDlyTg0_u1_p2 @'h2001d0 {
    field TxDqsDlyTg0_u1_p2 @0 {
       bits 10;
       access rw;
       reset 10'h100;
    }
  }
  register TxDqsDlyTg1_u1_p2 @'h2001d1 {
    field TxDqsDlyTg1_u1_p2 @0 {
       bits 10;
       access rw;
       reset 10'h100;
    }
  }
  register TxDqsDlyTg2_u1_p2 @'h2001d2 {
    field TxDqsDlyTg2_u1_p2 @0 {
       bits 10;
       access rw;
       reset 10'h100;
    }
  }
  register TxDqsDlyTg3_u1_p2 @'h2001d3 {
    field TxDqsDlyTg3_u1_p2 @0 {
       bits 10;
       access rw;
       reset 10'h100;
    }
  }
  register TxDqDlyTg0_r2_p2 @'h2002c0 {
    field TxDqDlyTg0_r2_p2 @0 {
       bits 9;
       access rw;
       reset 9'h10;
    }
  }
  register TxDqDlyTg1_r2_p2 @'h2002c1 {
    field TxDqDlyTg1_r2_p2 @0 {
       bits 9;
       access rw;
       reset 9'h10;
    }
  }
  register TxDqDlyTg2_r2_p2 @'h2002c2 {
    field TxDqDlyTg2_r2_p2 @0 {
       bits 9;
       access rw;
       reset 9'h10;
    }
  }
  register TxDqDlyTg3_r2_p2 @'h2002c3 {
    field TxDqDlyTg3_r2_p2 @0 {
       bits 9;
       access rw;
       reset 9'h10;
    }
  }
  register TxDqDlyTg0_r3_p2 @'h2003c0 {
    field TxDqDlyTg0_r3_p2 @0 {
       bits 9;
       access rw;
       reset 9'h10;
    }
  }
  register TxDqDlyTg1_r3_p2 @'h2003c1 {
    field TxDqDlyTg1_r3_p2 @0 {
       bits 9;
       access rw;
       reset 9'h10;
    }
  }
  register TxDqDlyTg2_r3_p2 @'h2003c2 {
    field TxDqDlyTg2_r3_p2 @0 {
       bits 9;
       access rw;
       reset 9'h10;
    }
  }
  register TxDqDlyTg3_r3_p2 @'h2003c3 {
    field TxDqDlyTg3_r3_p2 @0 {
       bits 9;
       access rw;
       reset 9'h10;
    }
  }
  register TxDqDlyTg0_r4_p2 @'h2004c0 {
    field TxDqDlyTg0_r4_p2 @0 {
       bits 9;
       access rw;
       reset 9'h10;
    }
  }
  register TxDqDlyTg1_r4_p2 @'h2004c1 {
    field TxDqDlyTg1_r4_p2 @0 {
       bits 9;
       access rw;
       reset 9'h10;
    }
  }
  register TxDqDlyTg2_r4_p2 @'h2004c2 {
    field TxDqDlyTg2_r4_p2 @0 {
       bits 9;
       access rw;
       reset 9'h10;
    }
  }
  register TxDqDlyTg3_r4_p2 @'h2004c3 {
    field TxDqDlyTg3_r4_p2 @0 {
       bits 9;
       access rw;
       reset 9'h10;
    }
  }
  register TxDqDlyTg0_r5_p2 @'h2005c0 {
    field TxDqDlyTg0_r5_p2 @0 {
       bits 9;
       access rw;
       reset 9'h10;
    }
  }
  register TxDqDlyTg1_r5_p2 @'h2005c1 {
    field TxDqDlyTg1_r5_p2 @0 {
       bits 9;
       access rw;
       reset 9'h10;
    }
  }
  register TxDqDlyTg2_r5_p2 @'h2005c2 {
    field TxDqDlyTg2_r5_p2 @0 {
       bits 9;
       access rw;
       reset 9'h10;
    }
  }
  register TxDqDlyTg3_r5_p2 @'h2005c3 {
    field TxDqDlyTg3_r5_p2 @0 {
       bits 9;
       access rw;
       reset 9'h10;
    }
  }
  register TxDqDlyTg0_r6_p2 @'h2006c0 {
    field TxDqDlyTg0_r6_p2 @0 {
       bits 9;
       access rw;
       reset 9'h10;
    }
  }
  register TxDqDlyTg1_r6_p2 @'h2006c1 {
    field TxDqDlyTg1_r6_p2 @0 {
       bits 9;
       access rw;
       reset 9'h10;
    }
  }
  register TxDqDlyTg2_r6_p2 @'h2006c2 {
    field TxDqDlyTg2_r6_p2 @0 {
       bits 9;
       access rw;
       reset 9'h10;
    }
  }
  register TxDqDlyTg3_r6_p2 @'h2006c3 {
    field TxDqDlyTg3_r6_p2 @0 {
       bits 9;
       access rw;
       reset 9'h10;
    }
  }
  register TxDqDlyTg0_r7_p2 @'h2007c0 {
    field TxDqDlyTg0_r7_p2 @0 {
       bits 9;
       access rw;
       reset 9'h10;
    }
  }
  register TxDqDlyTg1_r7_p2 @'h2007c1 {
    field TxDqDlyTg1_r7_p2 @0 {
       bits 9;
       access rw;
       reset 9'h10;
    }
  }
  register TxDqDlyTg2_r7_p2 @'h2007c2 {
    field TxDqDlyTg2_r7_p2 @0 {
       bits 9;
       access rw;
       reset 9'h10;
    }
  }
  register TxDqDlyTg3_r7_p2 @'h2007c3 {
    field TxDqDlyTg3_r7_p2 @0 {
       bits 9;
       access rw;
       reset 9'h10;
    }
  }
  register TxDqDlyTg0_r8_p2 @'h2008c0 {
    field TxDqDlyTg0_r8_p2 @0 {
       bits 9;
       access rw;
       reset 9'h10;
    }
  }
  register TxDqDlyTg1_r8_p2 @'h2008c1 {
    field TxDqDlyTg1_r8_p2 @0 {
       bits 9;
       access rw;
       reset 9'h10;
    }
  }
  register TxDqDlyTg2_r8_p2 @'h2008c2 {
    field TxDqDlyTg2_r8_p2 @0 {
       bits 9;
       access rw;
       reset 9'h10;
    }
  }
  register TxDqDlyTg3_r8_p2 @'h2008c3 {
    field TxDqDlyTg3_r8_p2 @0 {
       bits 9;
       access rw;
       reset 9'h10;
    }
  }
  register UseDqsEnReplica_p3 @'h300003 {
    field UseDqsEnReplica_p3 @0 {
       bits 1;
       access rw;
       reset 1'h0;
    }
  }
  register DFIMRL_p3 @'h300020 {
    field DFIMRL_p3 @0 {
       bits 5;
       access rw;
       reset 5'h6;
    }
  }
  register TxImpedanceCtrl0_b0_p3 @'h300041 {
    field DrvStrenDqP @0 {
       bits 6;
       access rw;
       reset 6'h3f;
    }
    field DrvStrenDqN @6 {
       bits 6;
       access rw;
       reset 6'h3f;
    }
  }
  register DqDqsRcvCntrl_b0_p3 @'h300043 {
    field SelAnalogVref @0 {
       bits 1;
       access rw;
       reset 1'h0;
    }
    field ExtVrefRange @1 {
       bits 1;
       access rw;
       reset 1'h0;
    }
    field DfeCtrl @2 {
       bits 2;
       access rw;
       reset 2'h0;
    }
    field MajorModeDbyte @4 {
       bits 3;
       access rw;
       reset 3'h3;
    }
    field GainCurrAdj @7 {
       bits 5;
       access rw;
       reset 5'hb;
    }
    field Reserved @12 {
       bits 4;
    }
  }
  register TxEqualizationMode_p3 @'h300048 {
    field TxEqMode @0 {
       bits 2;
       access rw;
       reset 2'h0;
    }
  }
  register TxImpedanceCtrl1_b0_p3 @'h300049 {
    field DrvStrenFSDqP @0 {
       bits 6;
       access rw;
       reset 6'h3f;
    }
    field DrvStrenFSDqN @6 {
       bits 6;
       access rw;
       reset 6'h3f;
    }
  }
  register TxImpedanceCtrl2_b0_p3 @'h30004b {
    field DrvStrenEQHiDqP @0 {
       bits 6;
       access rw;
       reset 6'h0;
    }
    field DrvStrenEQLoDqN @6 {
       bits 6;
       access rw;
       reset 6'h0;
    }
  }
  register DqDqsRcvCntrl2_p3 @'h30004c {
    field EnRxAgressivePDR @0 {
       bits 1;
       access rw;
       reset 1'h0;
    }
  }
  register TxOdtDrvStren_b0_p3 @'h30004d {
    field ODTStrenP @0 {
       bits 6;
       access rw;
       reset 6'h0;
    }
    field ODTStrenN @6 {
       bits 6;
       access rw;
       reset 6'h0;
    }
  }
  register TxSlewRate_b0_p3 @'h30005f {
    field TxPreP @0 {
       bits 4;
       access rw;
       reset 4'hf;
    }
    field TxPreN @4 {
       bits 4;
       access rw;
       reset 4'hf;
    }
    field TxPreDrvMode @8 {
       bits 3;
       access rw;
       reset 3'h7;
    }
  }
  register RxEnDlyTg0_u0_p3 @'h300080 {
    field RxEnDlyTg0_u0_p3 @0 {
       bits 11;
       access rw;
       reset 11'h100;
    }
  }
  register RxEnDlyTg1_u0_p3 @'h300081 {
    field RxEnDlyTg1_u0_p3 @0 {
       bits 11;
       access rw;
       reset 11'h100;
    }
  }
  register RxEnDlyTg2_u0_p3 @'h300082 {
    field RxEnDlyTg2_u0_p3 @0 {
       bits 11;
       access rw;
       reset 11'h100;
    }
  }
  register RxEnDlyTg3_u0_p3 @'h300083 {
    field RxEnDlyTg3_u0_p3 @0 {
       bits 11;
       access rw;
       reset 11'h100;
    }
  }
  register RxClkDlyTg0_u0_p3 @'h30008c {
    field RxClkDlyTg0_u0_p3 @0 {
       bits 6;
       access rw;
       reset 6'h10;
    }
  }
  register RxClkDlyTg1_u0_p3 @'h30008d {
    field RxClkDlyTg1_u0_p3 @0 {
       bits 6;
       access rw;
       reset 6'h10;
    }
  }
  register RxClkDlyTg2_u0_p3 @'h30008e {
    field RxClkDlyTg2_u0_p3 @0 {
       bits 6;
       access rw;
       reset 6'h10;
    }
  }
  register RxClkDlyTg3_u0_p3 @'h30008f {
    field RxClkDlyTg3_u0_p3 @0 {
       bits 6;
       access rw;
       reset 6'h10;
    }
  }
  register RxClkcDlyTg0_u0_p3 @'h300090 {
    field RxClkcDlyTg0_u0_p3 @0 {
       bits 6;
       access rw;
       reset 6'h10;
    }
  }
  register RxClkcDlyTg1_u0_p3 @'h300091 {
    field RxClkcDlyTg1_u0_p3 @0 {
       bits 6;
       access rw;
       reset 6'h10;
    }
  }
  register RxClkcDlyTg2_u0_p3 @'h300092 {
    field RxClkcDlyTg2_u0_p3 @0 {
       bits 6;
       access rw;
       reset 6'h10;
    }
  }
  register RxClkcDlyTg3_u0_p3 @'h300093 {
    field RxClkcDlyTg3_u0_p3 @0 {
       bits 6;
       access rw;
       reset 6'h10;
    }
  }
  register PptDqsCntInvTrnTg0_p3 @'h3000ae {
    field PptDqsCntInvTrnTg0_p3 @0 {
       bits 16;
       access rw;
       reset 16'h0;
    }
  }
  register PptDqsCntInvTrnTg1_p3 @'h3000af {
    field PptDqsCntInvTrnTg1_p3 @0 {
       bits 16;
       access rw;
       reset 16'h0;
    }
  }
  register TxDqDlyTg0_r0_p3 @'h3000c0 {
    field TxDqDlyTg0_r0_p3 @0 {
       bits 9;
       access rw;
       reset 9'h10;
    }
  }
  register TxDqDlyTg1_r0_p3 @'h3000c1 {
    field TxDqDlyTg1_r0_p3 @0 {
       bits 9;
       access rw;
       reset 9'h10;
    }
  }
  register TxDqDlyTg2_r0_p3 @'h3000c2 {
    field TxDqDlyTg2_r0_p3 @0 {
       bits 9;
       access rw;
       reset 9'h10;
    }
  }
  register TxDqDlyTg3_r0_p3 @'h3000c3 {
    field TxDqDlyTg3_r0_p3 @0 {
       bits 9;
       access rw;
       reset 9'h10;
    }
  }
  register TxDqsDlyTg0_u0_p3 @'h3000d0 {
    field TxDqsDlyTg0_u0_p3 @0 {
       bits 10;
       access rw;
       reset 10'h100;
    }
  }
  register TxDqsDlyTg1_u0_p3 @'h3000d1 {
    field TxDqsDlyTg1_u0_p3 @0 {
       bits 10;
       access rw;
       reset 10'h100;
    }
  }
  register TxDqsDlyTg2_u0_p3 @'h3000d2 {
    field TxDqsDlyTg2_u0_p3 @0 {
       bits 10;
       access rw;
       reset 10'h100;
    }
  }
  register TxDqsDlyTg3_u0_p3 @'h3000d3 {
    field TxDqsDlyTg3_u0_p3 @0 {
       bits 10;
       access rw;
       reset 10'h100;
    }
  }
  register TxImpedanceCtrl0_b1_p3 @'h300141 {
    field DrvStrenDqP @0 {
       bits 6;
       access rw;
       reset 6'h3f;
    }
    field DrvStrenDqN @6 {
       bits 6;
       access rw;
       reset 6'h3f;
    }
  }
  register DqDqsRcvCntrl_b1_p3 @'h300143 {
    field SelAnalogVref @0 {
       bits 1;
       access rw;
       reset 1'h0;
    }
    field ExtVrefRange @1 {
       bits 1;
       access rw;
       reset 1'h0;
    }
    field DfeCtrl @2 {
       bits 2;
       access rw;
       reset 2'h0;
    }
    field MajorModeDbyte @4 {
       bits 3;
       access rw;
       reset 3'h3;
    }
    field GainCurrAdj @7 {
       bits 5;
       access rw;
       reset 5'hb;
    }
    field Reserved @12 {
       bits 4;
    }
  }
  register TxImpedanceCtrl1_b1_p3 @'h300149 {
    field DrvStrenFSDqP @0 {
       bits 6;
       access rw;
       reset 6'h3f;
    }
    field DrvStrenFSDqN @6 {
       bits 6;
       access rw;
       reset 6'h3f;
    }
  }
  register TxImpedanceCtrl2_b1_p3 @'h30014b {
    field DrvStrenEQHiDqP @0 {
       bits 6;
       access rw;
       reset 6'h0;
    }
    field DrvStrenEQLoDqN @6 {
       bits 6;
       access rw;
       reset 6'h0;
    }
  }
  register TxOdtDrvStren_b1_p3 @'h30014d {
    field ODTStrenP @0 {
       bits 6;
       access rw;
       reset 6'h0;
    }
    field ODTStrenN @6 {
       bits 6;
       access rw;
       reset 6'h0;
    }
  }
  register TxSlewRate_b1_p3 @'h30015f {
    field TxPreP @0 {
       bits 4;
       access rw;
       reset 4'hf;
    }
    field TxPreN @4 {
       bits 4;
       access rw;
       reset 4'hf;
    }
    field TxPreDrvMode @8 {
       bits 3;
       access rw;
       reset 3'h7;
    }
  }
  register RxEnDlyTg0_u1_p3 @'h300180 {
    field RxEnDlyTg0_u1_p3 @0 {
       bits 11;
       access rw;
       reset 11'h100;
    }
  }
  register RxEnDlyTg1_u1_p3 @'h300181 {
    field RxEnDlyTg1_u1_p3 @0 {
       bits 11;
       access rw;
       reset 11'h100;
    }
  }
  register RxEnDlyTg2_u1_p3 @'h300182 {
    field RxEnDlyTg2_u1_p3 @0 {
       bits 11;
       access rw;
       reset 11'h100;
    }
  }
  register RxEnDlyTg3_u1_p3 @'h300183 {
    field RxEnDlyTg3_u1_p3 @0 {
       bits 11;
       access rw;
       reset 11'h100;
    }
  }
  register RxClkDlyTg0_u1_p3 @'h30018c {
    field RxClkDlyTg0_u1_p3 @0 {
       bits 6;
       access rw;
       reset 6'h10;
    }
  }
  register RxClkDlyTg1_u1_p3 @'h30018d {
    field RxClkDlyTg1_u1_p3 @0 {
       bits 6;
       access rw;
       reset 6'h10;
    }
  }
  register RxClkDlyTg2_u1_p3 @'h30018e {
    field RxClkDlyTg2_u1_p3 @0 {
       bits 6;
       access rw;
       reset 6'h10;
    }
  }
  register RxClkDlyTg3_u1_p3 @'h30018f {
    field RxClkDlyTg3_u1_p3 @0 {
       bits 6;
       access rw;
       reset 6'h10;
    }
  }
  register RxClkcDlyTg0_u1_p3 @'h300190 {
    field RxClkcDlyTg0_u1_p3 @0 {
       bits 6;
       access rw;
       reset 6'h10;
    }
  }
  register RxClkcDlyTg1_u1_p3 @'h300191 {
    field RxClkcDlyTg1_u1_p3 @0 {
       bits 6;
       access rw;
       reset 6'h10;
    }
  }
  register RxClkcDlyTg2_u1_p3 @'h300192 {
    field RxClkcDlyTg2_u1_p3 @0 {
       bits 6;
       access rw;
       reset 6'h10;
    }
  }
  register RxClkcDlyTg3_u1_p3 @'h300193 {
    field RxClkcDlyTg3_u1_p3 @0 {
       bits 6;
       access rw;
       reset 6'h10;
    }
  }
  register TxDqDlyTg0_r1_p3 @'h3001c0 {
    field TxDqDlyTg0_r1_p3 @0 {
       bits 9;
       access rw;
       reset 9'h10;
    }
  }
  register TxDqDlyTg1_r1_p3 @'h3001c1 {
    field TxDqDlyTg1_r1_p3 @0 {
       bits 9;
       access rw;
       reset 9'h10;
    }
  }
  register TxDqDlyTg2_r1_p3 @'h3001c2 {
    field TxDqDlyTg2_r1_p3 @0 {
       bits 9;
       access rw;
       reset 9'h10;
    }
  }
  register TxDqDlyTg3_r1_p3 @'h3001c3 {
    field TxDqDlyTg3_r1_p3 @0 {
       bits 9;
       access rw;
       reset 9'h10;
    }
  }
  register TxDqsDlyTg0_u1_p3 @'h3001d0 {
    field TxDqsDlyTg0_u1_p3 @0 {
       bits 10;
       access rw;
       reset 10'h100;
    }
  }
  register TxDqsDlyTg1_u1_p3 @'h3001d1 {
    field TxDqsDlyTg1_u1_p3 @0 {
       bits 10;
       access rw;
       reset 10'h100;
    }
  }
  register TxDqsDlyTg2_u1_p3 @'h3001d2 {
    field TxDqsDlyTg2_u1_p3 @0 {
       bits 10;
       access rw;
       reset 10'h100;
    }
  }
  register TxDqsDlyTg3_u1_p3 @'h3001d3 {
    field TxDqsDlyTg3_u1_p3 @0 {
       bits 10;
       access rw;
       reset 10'h100;
    }
  }
  register TxDqDlyTg0_r2_p3 @'h3002c0 {
    field TxDqDlyTg0_r2_p3 @0 {
       bits 9;
       access rw;
       reset 9'h10;
    }
  }
  register TxDqDlyTg1_r2_p3 @'h3002c1 {
    field TxDqDlyTg1_r2_p3 @0 {
       bits 9;
       access rw;
       reset 9'h10;
    }
  }
  register TxDqDlyTg2_r2_p3 @'h3002c2 {
    field TxDqDlyTg2_r2_p3 @0 {
       bits 9;
       access rw;
       reset 9'h10;
    }
  }
  register TxDqDlyTg3_r2_p3 @'h3002c3 {
    field TxDqDlyTg3_r2_p3 @0 {
       bits 9;
       access rw;
       reset 9'h10;
    }
  }
  register TxDqDlyTg0_r3_p3 @'h3003c0 {
    field TxDqDlyTg0_r3_p3 @0 {
       bits 9;
       access rw;
       reset 9'h10;
    }
  }
  register TxDqDlyTg1_r3_p3 @'h3003c1 {
    field TxDqDlyTg1_r3_p3 @0 {
       bits 9;
       access rw;
       reset 9'h10;
    }
  }
  register TxDqDlyTg2_r3_p3 @'h3003c2 {
    field TxDqDlyTg2_r3_p3 @0 {
       bits 9;
       access rw;
       reset 9'h10;
    }
  }
  register TxDqDlyTg3_r3_p3 @'h3003c3 {
    field TxDqDlyTg3_r3_p3 @0 {
       bits 9;
       access rw;
       reset 9'h10;
    }
  }
  register TxDqDlyTg0_r4_p3 @'h3004c0 {
    field TxDqDlyTg0_r4_p3 @0 {
       bits 9;
       access rw;
       reset 9'h10;
    }
  }
  register TxDqDlyTg1_r4_p3 @'h3004c1 {
    field TxDqDlyTg1_r4_p3 @0 {
       bits 9;
       access rw;
       reset 9'h10;
    }
  }
  register TxDqDlyTg2_r4_p3 @'h3004c2 {
    field TxDqDlyTg2_r4_p3 @0 {
       bits 9;
       access rw;
       reset 9'h10;
    }
  }
  register TxDqDlyTg3_r4_p3 @'h3004c3 {
    field TxDqDlyTg3_r4_p3 @0 {
       bits 9;
       access rw;
       reset 9'h10;
    }
  }
  register TxDqDlyTg0_r5_p3 @'h3005c0 {
    field TxDqDlyTg0_r5_p3 @0 {
       bits 9;
       access rw;
       reset 9'h10;
    }
  }
  register TxDqDlyTg1_r5_p3 @'h3005c1 {
    field TxDqDlyTg1_r5_p3 @0 {
       bits 9;
       access rw;
       reset 9'h10;
    }
  }
  register TxDqDlyTg2_r5_p3 @'h3005c2 {
    field TxDqDlyTg2_r5_p3 @0 {
       bits 9;
       access rw;
       reset 9'h10;
    }
  }
  register TxDqDlyTg3_r5_p3 @'h3005c3 {
    field TxDqDlyTg3_r5_p3 @0 {
       bits 9;
       access rw;
       reset 9'h10;
    }
  }
  register TxDqDlyTg0_r6_p3 @'h3006c0 {
    field TxDqDlyTg0_r6_p3 @0 {
       bits 9;
       access rw;
       reset 9'h10;
    }
  }
  register TxDqDlyTg1_r6_p3 @'h3006c1 {
    field TxDqDlyTg1_r6_p3 @0 {
       bits 9;
       access rw;
       reset 9'h10;
    }
  }
  register TxDqDlyTg2_r6_p3 @'h3006c2 {
    field TxDqDlyTg2_r6_p3 @0 {
       bits 9;
       access rw;
       reset 9'h10;
    }
  }
  register TxDqDlyTg3_r6_p3 @'h3006c3 {
    field TxDqDlyTg3_r6_p3 @0 {
       bits 9;
       access rw;
       reset 9'h10;
    }
  }
  register TxDqDlyTg0_r7_p3 @'h3007c0 {
    field TxDqDlyTg0_r7_p3 @0 {
       bits 9;
       access rw;
       reset 9'h10;
    }
  }
  register TxDqDlyTg1_r7_p3 @'h3007c1 {
    field TxDqDlyTg1_r7_p3 @0 {
       bits 9;
       access rw;
       reset 9'h10;
    }
  }
  register TxDqDlyTg2_r7_p3 @'h3007c2 {
    field TxDqDlyTg2_r7_p3 @0 {
       bits 9;
       access rw;
       reset 9'h10;
    }
  }
  register TxDqDlyTg3_r7_p3 @'h3007c3 {
    field TxDqDlyTg3_r7_p3 @0 {
       bits 9;
       access rw;
       reset 9'h10;
    }
  }
  register TxDqDlyTg0_r8_p3 @'h3008c0 {
    field TxDqDlyTg0_r8_p3 @0 {
       bits 9;
       access rw;
       reset 9'h10;
    }
  }
  register TxDqDlyTg1_r8_p3 @'h3008c1 {
    field TxDqDlyTg1_r8_p3 @0 {
       bits 9;
       access rw;
       reset 9'h10;
    }
  }
  register TxDqDlyTg2_r8_p3 @'h3008c2 {
    field TxDqDlyTg2_r8_p3 @0 {
       bits 9;
       access rw;
       reset 9'h10;
    }
  }
  register TxDqDlyTg3_r8_p3 @'h3008c3 {
    field TxDqDlyTg3_r8_p3 @0 {
       bits 9;
       access rw;
       reset 9'h10;
    }
  }
}
block dwc_ddrphy_top_DWC_DDRPHYA_DBYTE4 {
  endian little;
  bytes 2;
  register DbyteMiscMode @'h0 {
    field Reserved @0 {
       bits 2;
    }
    field DByteDisable @2 {
       bits 1;
       access rw;
       reset 1'h0;
    }
  }
  register TsmByte0 @'h1 {
    field RFU_TsmByte0 @0 {
       bits 16;
       access rw;
       reset 16'h0;
    }
  }
  register TrainingParam @'h2 {
    field RFU_TrainingParam @0 {
       bits 16;
       access rw;
       reset 16'h0;
    }
  }
  register UseDqsEnReplica_p0 @'h3 {
    field UseDqsEnReplica_p0 @0 {
       bits 1;
       access rw;
       reset 1'h0;
    }
  }
  register RxTrainPatternEnable @'h10 {
    field RxTrainPatternEnable @0 {
       bits 1;
       access rw;
       reset 1'h0;
    }
  }
  register TsmByte1 @'h11 {
    field RFU_TsmByte1 @0 {
       bits 16;
       access rw;
       reset 16'h0;
    }
  }
  register TsmByte2 @'h12 {
    field RFU_TsmByte2 @0 {
       bits 16;
       access rw;
       reset 16'h0;
    }
  }
  register TsmByte3 @'h13 {
    field RFU_TsmByte3 @0 {
       bits 9;
       access rw;
       reset 9'h0;
    }
  }
  register TsmByte4 @'h14 {
    field RFU_TsmByte4 @0 {
       bits 4;
       access rw;
       reset 4'h0;
    }
  }
  register TestModeConfig @'h17 {
    field RFU_TestModeConfig @0 {
       bits 10;
       access rw;
       reset 10'h0;
    }
  }
  register TsmByte5 @'h18 {
    field RFU_TsmByte5 @0 {
       bits 16;
       access rw;
       reset 16'h0;
    }
  }
  register MtestMuxSel @'h1a {
    field MtestMuxSel @0 {
       bits 6;
       access rw;
       reset 6'h0;
    }
  }
  register DtsmTrainModeCtrl @'h1f {
    field RFU_DtsmTrainModeCtrl @0 {
       bits 4;
       access rw;
       reset 4'h0;
    }
  }
  register DFIMRL_p0 @'h20 {
    field DFIMRL_p0 @0 {
       bits 5;
       access rw;
       reset 5'h6;
    }
  }
  register AsyncDbyteMode @'h24 {
    field AsyncDbyteMode @0 {
       bits 9;
       access rw;
       reset 9'h0;
    }
  }
  register AsyncDbyteTxEn @'h26 {
    field AsyncDbyteTxEn @0 {
       bits 12;
       access rw;
       reset 12'h0;
    }
  }
  register AsyncDbyteTxData @'h28 {
    field AsyncDbyteTxData @0 {
       bits 12;
       access rw;
       reset 12'h0;
    }
  }
  register AsyncDbyteRxData @'h2a {
    field AsyncDbyteRxData @0 {
       bits 12;
       access ro;
       reset 12'h0;
    }
  }
  register VrefDAC1_r0 @'h30 {
    field VrefDAC1_r0 @0 {
       bits 7;
       access rw;
       reset 7'h0;
    }
  }
  register TrainingCntr_r0 @'h32 {
    field RFU_TrainingCntr_r0 @0 {
       bits 16;
       access rw;
       reset 16'h0;
    }
  }
  register VrefDAC0_r0 @'h40 {
    field VrefDAC0_r0 @0 {
       bits 7;
       access rw;
       reset 7'h0;
    }
  }
  register TxImpedanceCtrl0_b0_p0 @'h41 {
    field DrvStrenDqP @0 {
       bits 6;
       access rw;
       reset 6'h3f;
    }
    field DrvStrenDqN @6 {
       bits 6;
       access rw;
       reset 6'h3f;
    }
  }
  register DqDqsRcvCntrl_b0_p0 @'h43 {
    field SelAnalogVref @0 {
       bits 1;
       access rw;
       reset 1'h0;
    }
    field ExtVrefRange @1 {
       bits 1;
       access rw;
       reset 1'h0;
    }
    field DfeCtrl @2 {
       bits 2;
       access rw;
       reset 2'h0;
    }
    field MajorModeDbyte @4 {
       bits 3;
       access rw;
       reset 3'h3;
    }
    field GainCurrAdj @7 {
       bits 5;
       access rw;
       reset 5'hb;
    }
    field Reserved @12 {
       bits 4;
    }
  }
  register TxEqualizationMode_p0 @'h48 {
    field TxEqMode @0 {
       bits 2;
       access rw;
       reset 2'h0;
    }
  }
  register TxImpedanceCtrl1_b0_p0 @'h49 {
    field DrvStrenFSDqP @0 {
       bits 6;
       access rw;
       reset 6'h3f;
    }
    field DrvStrenFSDqN @6 {
       bits 6;
       access rw;
       reset 6'h3f;
    }
  }
  register DqDqsRcvCntrl1 @'h4a {
    field PowerDownRcvr @0 {
       bits 9;
       access rw;
       reset 9'h0;
    }
    field PowerDownRcvrDqs @9 {
       bits 1;
       access rw;
       reset 1'h0;
    }
    field RxPadStandbyEn @10 {
       bits 1;
       access rw;
       reset 1'h1;
    }
    field EnLPReqPDR @11 {
       bits 1;
       access rw;
       reset 1'h0;
    }
  }
  register TxImpedanceCtrl2_b0_p0 @'h4b {
    field DrvStrenEQHiDqP @0 {
       bits 6;
       access rw;
       reset 6'h0;
    }
    field DrvStrenEQLoDqN @6 {
       bits 6;
       access rw;
       reset 6'h0;
    }
  }
  register DqDqsRcvCntrl2_p0 @'h4c {
    field EnRxAgressivePDR @0 {
       bits 1;
       access rw;
       reset 1'h0;
    }
  }
  register TxOdtDrvStren_b0_p0 @'h4d {
    field ODTStrenP @0 {
       bits 6;
       access rw;
       reset 6'h0;
    }
    field ODTStrenN @6 {
       bits 6;
       access rw;
       reset 6'h0;
    }
  }
  register RxFifoCheckStatus @'h56 {
    field RxFifoLocErr @0 {
       bits 1;
       access ro;
       reset 1'h0;
    }
    field RxFifoLocUErr @1 {
       bits 1;
       access ro;
       reset 1'h0;
    }
  }
  register RxFifoCheckErrValues @'h57 {
    field RxFifoRdLocErrValue @0 {
       bits 4;
       access ro;
       reset 4'h0;
    }
    field RxFifoWrLocErrValue @4 {
       bits 4;
       access ro;
       reset 4'h0;
    }
    field RxFifoRdLocUErrValue @8 {
       bits 4;
       access ro;
       reset 4'h0;
    }
    field RxFifoWrLocUErrValue @12 {
       bits 4;
       access ro;
       reset 4'h0;
    }
  }
  register RxFifoInfo @'h58 {
    field RxFifoRdLoc @0 {
       bits 4;
       access ro;
       reset 4'h0;
    }
    field RxFifoWrLoc @4 {
       bits 4;
       access ro;
       reset 4'h0;
    }
    field RxFifoRdLocU @8 {
       bits 4;
       access ro;
       reset 4'h0;
    }
    field RxFifoWrLocU @12 {
       bits 4;
       access ro;
       reset 4'h0;
    }
  }
  register RxFifoVisibility @'h59 {
    field RxFifoRdPtr @0 {
       bits 3;
       access rw;
       reset 3'h0;
    }
    field RxFifoRdPtrOvr @3 {
       bits 1;
       access rw;
       reset 1'h0;
    }
    field RxFifoRdEn @4 {
       bits 1;
       access rw;
       reset 1'h0;
    }
  }
  register RxFifoContentsDQ3210 @'h5a {
    field RxFifoContentsDQ3210 @0 {
       bits 16;
       access ro;
       reset 16'h0;
    }
  }
  register RxFifoContentsDQ7654 @'h5b {
    field RxFifoContentsDQ7654 @0 {
       bits 16;
       access ro;
       reset 16'h0;
    }
  }
  register RxFifoContentsDBI @'h5c {
    field RxFifoContentsDBI @0 {
       bits 4;
       access ro;
       reset 4'h0;
    }
  }
  register TxSlewRate_b0_p0 @'h5f {
    field TxPreP @0 {
       bits 4;
       access rw;
       reset 4'hf;
    }
    field TxPreN @4 {
       bits 4;
       access rw;
       reset 4'hf;
    }
    field TxPreDrvMode @8 {
       bits 3;
       access rw;
       reset 3'h7;
    }
  }
  register TrainingIncDecDtsmEn_r0 @'h62 {
    field TrainingIncDecDtsmEn_r0 @0 {
       bits 9;
       access rw;
       reset 9'h0;
    }
  }
  register RxPBDlyTg0_r0 @'h68 {
    field RxPBDlyTg0_r0 @0 {
       bits 7;
       access rw;
       reset 7'h0;
    }
  }
  register RxPBDlyTg1_r0 @'h69 {
    field RxPBDlyTg1_r0 @0 {
       bits 7;
       access rw;
       reset 7'h0;
    }
  }
  register RxPBDlyTg2_r0 @'h6a {
    field RxPBDlyTg2_r0 @0 {
       bits 7;
       access rw;
       reset 7'h0;
    }
  }
  register RxPBDlyTg3_r0 @'h6b {
    field RxPBDlyTg3_r0 @0 {
       bits 7;
       access rw;
       reset 7'h0;
    }
  }
  register RxEnDlyTg0_u0_p0 @'h80 {
    field RxEnDlyTg0_u0_p0 @0 {
       bits 11;
       access rw;
       reset 11'h100;
    }
  }
  register RxEnDlyTg1_u0_p0 @'h81 {
    field RxEnDlyTg1_u0_p0 @0 {
       bits 11;
       access rw;
       reset 11'h100;
    }
  }
  register RxEnDlyTg2_u0_p0 @'h82 {
    field RxEnDlyTg2_u0_p0 @0 {
       bits 11;
       access rw;
       reset 11'h100;
    }
  }
  register RxEnDlyTg3_u0_p0 @'h83 {
    field RxEnDlyTg3_u0_p0 @0 {
       bits 11;
       access rw;
       reset 11'h100;
    }
  }
  register RxClkDlyTg0_u0_p0 @'h8c {
    field RxClkDlyTg0_u0_p0 @0 {
       bits 6;
       access rw;
       reset 6'h10;
    }
  }
  register RxClkDlyTg1_u0_p0 @'h8d {
    field RxClkDlyTg1_u0_p0 @0 {
       bits 6;
       access rw;
       reset 6'h10;
    }
  }
  register RxClkDlyTg2_u0_p0 @'h8e {
    field RxClkDlyTg2_u0_p0 @0 {
       bits 6;
       access rw;
       reset 6'h10;
    }
  }
  register RxClkDlyTg3_u0_p0 @'h8f {
    field RxClkDlyTg3_u0_p0 @0 {
       bits 6;
       access rw;
       reset 6'h10;
    }
  }
  register RxClkcDlyTg0_u0_p0 @'h90 {
    field RxClkcDlyTg0_u0_p0 @0 {
       bits 6;
       access rw;
       reset 6'h10;
    }
  }
  register RxClkcDlyTg1_u0_p0 @'h91 {
    field RxClkcDlyTg1_u0_p0 @0 {
       bits 6;
       access rw;
       reset 6'h10;
    }
  }
  register RxClkcDlyTg2_u0_p0 @'h92 {
    field RxClkcDlyTg2_u0_p0 @0 {
       bits 6;
       access rw;
       reset 6'h10;
    }
  }
  register RxClkcDlyTg3_u0_p0 @'h93 {
    field RxClkcDlyTg3_u0_p0 @0 {
       bits 6;
       access rw;
       reset 6'h10;
    }
  }
  register Dq0LnSel @'ha0 {
    field Dq0LnSel @0 {
       bits 3;
       access rw;
       reset 3'h0;
    }
  }
  register Dq1LnSel @'ha1 {
    field Dq1LnSel @0 {
       bits 3;
       access rw;
       reset 3'h1;
    }
  }
  register Dq2LnSel @'ha2 {
    field Dq2LnSel @0 {
       bits 3;
       access rw;
       reset 3'h2;
    }
  }
  register Dq3LnSel @'ha3 {
    field Dq3LnSel @0 {
       bits 3;
       access rw;
       reset 3'h3;
    }
  }
  register Dq4LnSel @'ha4 {
    field Dq4LnSel @0 {
       bits 3;
       access rw;
       reset 3'h4;
    }
  }
  register Dq5LnSel @'ha5 {
    field Dq5LnSel @0 {
       bits 3;
       access rw;
       reset 3'h5;
    }
  }
  register Dq6LnSel @'ha6 {
    field Dq6LnSel @0 {
       bits 3;
       access rw;
       reset 3'h6;
    }
  }
  register Dq7LnSel @'ha7 {
    field Dq7LnSel @0 {
       bits 3;
       access rw;
       reset 3'h7;
    }
  }
  register PptCtlStatic @'haa {
    field RFU_PptCtlStatic @0 {
       bits 12;
       access rw;
       reset 12'h0;
    }
  }
  register PptCtlDyn @'hab {
    field RFU_PptCtlDyn @0 {
       bits 2;
       access rw;
       reset 2'h0;
    }
  }
  register PptInfo @'hac {
    field PptInfo @0 {
       bits 16;
       access ro;
       reset 16'h0;
    }
  }
  register PptRxEnEvnt @'had {
    field RFU_PptRxEnEvnt @0 {
       bits 2;
       access rw;
       reset 2'h0;
    }
  }
  register PptDqsCntInvTrnTg0_p0 @'hae {
    field PptDqsCntInvTrnTg0_p0 @0 {
       bits 16;
       access rw;
       reset 16'h0;
    }
  }
  register PptDqsCntInvTrnTg1_p0 @'haf {
    field PptDqsCntInvTrnTg1_p0 @0 {
       bits 16;
       access rw;
       reset 16'h0;
    }
  }
  register DtsmBlankingCtrl @'hb1 {
    field RFU_DtsmBlankingCtrl @0 {
       bits 10;
       access rw;
       reset 10'h0;
    }
  }
  register Tsm0_i0 @'hb2 {
    field RFU_Tsm0_i0 @0 {
       bits 14;
       access rw;
       reset 14'h0;
    }
  }
  register Tsm1_i0 @'hb3 {
    field RFU_Tsm1_i0 @0 {
       bits 16;
       access ro;
       reset 16'h0;
    }
  }
  register Tsm2_i0 @'hb4 {
    field RFU_Tsm2_i0 @0 {
       bits 1;
       access rw;
       reset 1'h0;
    }
  }
  register Tsm3 @'hb5 {
    field RFU_Tsm3 @0 {
       bits 10;
       access rw;
       reset 10'h0;
    }
  }
  register TxChkDataSelects @'hb6 {
    field RFU_TxChkDataSelects @0 {
       bits 2;
       access rw;
       reset 2'h0;
    }
  }
  register DtsmUpThldXingInd @'hb7 {
    field DtsmUpThldXingInd @0 {
       bits 9;
       access ro;
       reset 9'h0;
    }
  }
  register DtsmLoThldXingInd @'hb8 {
    field DtsmLoThldXingInd @0 {
       bits 9;
       access ro;
       reset 9'h0;
    }
  }
  register DbyteAllDtsmCtrl0 @'hb9 {
    field RFU_DbyteAllDtsmCtrl0 @0 {
       bits 9;
       access rw;
       reset 9'h0;
    }
  }
  register DbyteAllDtsmCtrl1 @'hba {
    field RFU_DbyteAllDtsmCtrl1 @0 {
       bits 9;
       access rw;
       reset 9'h0;
    }
  }
  register DbyteAllDtsmCtrl2 @'hbb {
    field RFU_DbyteAllDtsmCtrl2 @0 {
       bits 9;
       access rw;
       reset 9'h0;
    }
  }
  register TxDqDlyTg0_r0_p0 @'hc0 {
    field TxDqDlyTg0_r0_p0 @0 {
       bits 9;
       access rw;
       reset 9'h10;
    }
  }
  register TxDqDlyTg1_r0_p0 @'hc1 {
    field TxDqDlyTg1_r0_p0 @0 {
       bits 9;
       access rw;
       reset 9'h10;
    }
  }
  register TxDqDlyTg2_r0_p0 @'hc2 {
    field TxDqDlyTg2_r0_p0 @0 {
       bits 9;
       access rw;
       reset 9'h10;
    }
  }
  register TxDqDlyTg3_r0_p0 @'hc3 {
    field TxDqDlyTg3_r0_p0 @0 {
       bits 9;
       access rw;
       reset 9'h10;
    }
  }
  register TxDqsDlyTg0_u0_p0 @'hd0 {
    field TxDqsDlyTg0_u0_p0 @0 {
       bits 10;
       access rw;
       reset 10'h100;
    }
  }
  register TxDqsDlyTg1_u0_p0 @'hd1 {
    field TxDqsDlyTg1_u0_p0 @0 {
       bits 10;
       access rw;
       reset 10'h100;
    }
  }
  register TxDqsDlyTg2_u0_p0 @'hd2 {
    field TxDqsDlyTg2_u0_p0 @0 {
       bits 10;
       access rw;
       reset 10'h100;
    }
  }
  register TxDqsDlyTg3_u0_p0 @'hd3 {
    field TxDqsDlyTg3_u0_p0 @0 {
       bits 10;
       access rw;
       reset 10'h100;
    }
  }
  register DxLcdlStatus @'he4 {
    field DxLcdlFineSnapVal @0 {
       bits 10;
       access ro;
       reset 10'h0;
    }
    field DxLcdlPhdSnapVal @10 {
       bits 1;
       access ro;
       reset 1'h0;
    }
    field DxLcdlStickyLock @11 {
       bits 1;
       access ro;
       reset 1'h0;
    }
    field DxLcdlStickyUnlock @12 {
       bits 1;
       access ro;
       reset 1'h0;
    }
    field DxLcdlLiveLock @13 {
       bits 1;
       access ro;
       reset 1'h0;
    }
  }
  register VrefDAC1_r1 @'h130 {
    field VrefDAC1_r1 @0 {
       bits 7;
       access rw;
       reset 7'h0;
    }
  }
  register TrainingCntr_r1 @'h132 {
    field RFU_TrainingCntr_r1 @0 {
       bits 16;
       access rw;
       reset 16'h0;
    }
  }
  register VrefDAC0_r1 @'h140 {
    field VrefDAC0_r1 @0 {
       bits 7;
       access rw;
       reset 7'h0;
    }
  }
  register TxImpedanceCtrl0_b1_p0 @'h141 {
    field DrvStrenDqP @0 {
       bits 6;
       access rw;
       reset 6'h3f;
    }
    field DrvStrenDqN @6 {
       bits 6;
       access rw;
       reset 6'h3f;
    }
  }
  register DqDqsRcvCntrl_b1_p0 @'h143 {
    field SelAnalogVref @0 {
       bits 1;
       access rw;
       reset 1'h0;
    }
    field ExtVrefRange @1 {
       bits 1;
       access rw;
       reset 1'h0;
    }
    field DfeCtrl @2 {
       bits 2;
       access rw;
       reset 2'h0;
    }
    field MajorModeDbyte @4 {
       bits 3;
       access rw;
       reset 3'h3;
    }
    field GainCurrAdj @7 {
       bits 5;
       access rw;
       reset 5'hb;
    }
    field Reserved @12 {
       bits 4;
    }
  }
  register TxImpedanceCtrl1_b1_p0 @'h149 {
    field DrvStrenFSDqP @0 {
       bits 6;
       access rw;
       reset 6'h3f;
    }
    field DrvStrenFSDqN @6 {
       bits 6;
       access rw;
       reset 6'h3f;
    }
  }
  register TxImpedanceCtrl2_b1_p0 @'h14b {
    field DrvStrenEQHiDqP @0 {
       bits 6;
       access rw;
       reset 6'h0;
    }
    field DrvStrenEQLoDqN @6 {
       bits 6;
       access rw;
       reset 6'h0;
    }
  }
  register TxOdtDrvStren_b1_p0 @'h14d {
    field ODTStrenP @0 {
       bits 6;
       access rw;
       reset 6'h0;
    }
    field ODTStrenN @6 {
       bits 6;
       access rw;
       reset 6'h0;
    }
  }
  register TxSlewRate_b1_p0 @'h15f {
    field TxPreP @0 {
       bits 4;
       access rw;
       reset 4'hf;
    }
    field TxPreN @4 {
       bits 4;
       access rw;
       reset 4'hf;
    }
    field TxPreDrvMode @8 {
       bits 3;
       access rw;
       reset 3'h7;
    }
  }
  register TrainingIncDecDtsmEn_r1 @'h162 {
    field TrainingIncDecDtsmEn_r1 @0 {
       bits 9;
       access rw;
       reset 9'h0;
    }
  }
  register RxPBDlyTg0_r1 @'h168 {
    field RxPBDlyTg0_r1 @0 {
       bits 7;
       access rw;
       reset 7'h0;
    }
  }
  register RxPBDlyTg1_r1 @'h169 {
    field RxPBDlyTg1_r1 @0 {
       bits 7;
       access rw;
       reset 7'h0;
    }
  }
  register RxPBDlyTg2_r1 @'h16a {
    field RxPBDlyTg2_r1 @0 {
       bits 7;
       access rw;
       reset 7'h0;
    }
  }
  register RxPBDlyTg3_r1 @'h16b {
    field RxPBDlyTg3_r1 @0 {
       bits 7;
       access rw;
       reset 7'h0;
    }
  }
  register RxEnDlyTg0_u1_p0 @'h180 {
    field RxEnDlyTg0_u1_p0 @0 {
       bits 11;
       access rw;
       reset 11'h100;
    }
  }
  register RxEnDlyTg1_u1_p0 @'h181 {
    field RxEnDlyTg1_u1_p0 @0 {
       bits 11;
       access rw;
       reset 11'h100;
    }
  }
  register RxEnDlyTg2_u1_p0 @'h182 {
    field RxEnDlyTg2_u1_p0 @0 {
       bits 11;
       access rw;
       reset 11'h100;
    }
  }
  register RxEnDlyTg3_u1_p0 @'h183 {
    field RxEnDlyTg3_u1_p0 @0 {
       bits 11;
       access rw;
       reset 11'h100;
    }
  }
  register RxClkDlyTg0_u1_p0 @'h18c {
    field RxClkDlyTg0_u1_p0 @0 {
       bits 6;
       access rw;
       reset 6'h10;
    }
  }
  register RxClkDlyTg1_u1_p0 @'h18d {
    field RxClkDlyTg1_u1_p0 @0 {
       bits 6;
       access rw;
       reset 6'h10;
    }
  }
  register RxClkDlyTg2_u1_p0 @'h18e {
    field RxClkDlyTg2_u1_p0 @0 {
       bits 6;
       access rw;
       reset 6'h10;
    }
  }
  register RxClkDlyTg3_u1_p0 @'h18f {
    field RxClkDlyTg3_u1_p0 @0 {
       bits 6;
       access rw;
       reset 6'h10;
    }
  }
  register RxClkcDlyTg0_u1_p0 @'h190 {
    field RxClkcDlyTg0_u1_p0 @0 {
       bits 6;
       access rw;
       reset 6'h10;
    }
  }
  register RxClkcDlyTg1_u1_p0 @'h191 {
    field RxClkcDlyTg1_u1_p0 @0 {
       bits 6;
       access rw;
       reset 6'h10;
    }
  }
  register RxClkcDlyTg2_u1_p0 @'h192 {
    field RxClkcDlyTg2_u1_p0 @0 {
       bits 6;
       access rw;
       reset 6'h10;
    }
  }
  register RxClkcDlyTg3_u1_p0 @'h193 {
    field RxClkcDlyTg3_u1_p0 @0 {
       bits 6;
       access rw;
       reset 6'h10;
    }
  }
  register Tsm0_i1 @'h1b2 {
    field RFU_Tsm0_i1 @0 {
       bits 14;
       access rw;
       reset 14'h0;
    }
  }
  register Tsm1_i1 @'h1b3 {
    field RFU_Tsm1_i1 @0 {
       bits 16;
       access ro;
       reset 16'h0;
    }
  }
  register Tsm2_i1 @'h1b4 {
    field RFU_Tsm2_i1 @0 {
       bits 1;
       access rw;
       reset 1'h0;
    }
  }
  register TxDqDlyTg0_r1_p0 @'h1c0 {
    field TxDqDlyTg0_r1_p0 @0 {
       bits 9;
       access rw;
       reset 9'h10;
    }
  }
  register TxDqDlyTg1_r1_p0 @'h1c1 {
    field TxDqDlyTg1_r1_p0 @0 {
       bits 9;
       access rw;
       reset 9'h10;
    }
  }
  register TxDqDlyTg2_r1_p0 @'h1c2 {
    field TxDqDlyTg2_r1_p0 @0 {
       bits 9;
       access rw;
       reset 9'h10;
    }
  }
  register TxDqDlyTg3_r1_p0 @'h1c3 {
    field TxDqDlyTg3_r1_p0 @0 {
       bits 9;
       access rw;
       reset 9'h10;
    }
  }
  register TxDqsDlyTg0_u1_p0 @'h1d0 {
    field TxDqsDlyTg0_u1_p0 @0 {
       bits 10;
       access rw;
       reset 10'h100;
    }
  }
  register TxDqsDlyTg1_u1_p0 @'h1d1 {
    field TxDqsDlyTg1_u1_p0 @0 {
       bits 10;
       access rw;
       reset 10'h100;
    }
  }
  register TxDqsDlyTg2_u1_p0 @'h1d2 {
    field TxDqsDlyTg2_u1_p0 @0 {
       bits 10;
       access rw;
       reset 10'h100;
    }
  }
  register TxDqsDlyTg3_u1_p0 @'h1d3 {
    field TxDqsDlyTg3_u1_p0 @0 {
       bits 10;
       access rw;
       reset 10'h100;
    }
  }
  register VrefDAC1_r2 @'h230 {
    field VrefDAC1_r2 @0 {
       bits 7;
       access rw;
       reset 7'h0;
    }
  }
  register TrainingCntr_r2 @'h232 {
    field RFU_TrainingCntr_r2 @0 {
       bits 16;
       access rw;
       reset 16'h0;
    }
  }
  register VrefDAC0_r2 @'h240 {
    field VrefDAC0_r2 @0 {
       bits 7;
       access rw;
       reset 7'h0;
    }
  }
  register TrainingIncDecDtsmEn_r2 @'h262 {
    field TrainingIncDecDtsmEn_r2 @0 {
       bits 9;
       access rw;
       reset 9'h0;
    }
  }
  register RxPBDlyTg0_r2 @'h268 {
    field RxPBDlyTg0_r2 @0 {
       bits 7;
       access rw;
       reset 7'h0;
    }
  }
  register RxPBDlyTg1_r2 @'h269 {
    field RxPBDlyTg1_r2 @0 {
       bits 7;
       access rw;
       reset 7'h0;
    }
  }
  register RxPBDlyTg2_r2 @'h26a {
    field RxPBDlyTg2_r2 @0 {
       bits 7;
       access rw;
       reset 7'h0;
    }
  }
  register RxPBDlyTg3_r2 @'h26b {
    field RxPBDlyTg3_r2 @0 {
       bits 7;
       access rw;
       reset 7'h0;
    }
  }
  register Tsm0_i2 @'h2b2 {
    field RFU_Tsm0_i2 @0 {
       bits 14;
       access rw;
       reset 14'h0;
    }
  }
  register Tsm1_i2 @'h2b3 {
    field RFU_Tsm1_i2 @0 {
       bits 16;
       access ro;
       reset 16'h0;
    }
  }
  register Tsm2_i2 @'h2b4 {
    field RFU_Tsm2_i2 @0 {
       bits 1;
       access rw;
       reset 1'h0;
    }
  }
  register TxDqDlyTg0_r2_p0 @'h2c0 {
    field TxDqDlyTg0_r2_p0 @0 {
       bits 9;
       access rw;
       reset 9'h10;
    }
  }
  register TxDqDlyTg1_r2_p0 @'h2c1 {
    field TxDqDlyTg1_r2_p0 @0 {
       bits 9;
       access rw;
       reset 9'h10;
    }
  }
  register TxDqDlyTg2_r2_p0 @'h2c2 {
    field TxDqDlyTg2_r2_p0 @0 {
       bits 9;
       access rw;
       reset 9'h10;
    }
  }
  register TxDqDlyTg3_r2_p0 @'h2c3 {
    field TxDqDlyTg3_r2_p0 @0 {
       bits 9;
       access rw;
       reset 9'h10;
    }
  }
  register VrefDAC1_r3 @'h330 {
    field VrefDAC1_r3 @0 {
       bits 7;
       access rw;
       reset 7'h0;
    }
  }
  register TrainingCntr_r3 @'h332 {
    field RFU_TrainingCntr_r3 @0 {
       bits 16;
       access rw;
       reset 16'h0;
    }
  }
  register VrefDAC0_r3 @'h340 {
    field VrefDAC0_r3 @0 {
       bits 7;
       access rw;
       reset 7'h0;
    }
  }
  register TrainingIncDecDtsmEn_r3 @'h362 {
    field TrainingIncDecDtsmEn_r3 @0 {
       bits 9;
       access rw;
       reset 9'h0;
    }
  }
  register RxPBDlyTg0_r3 @'h368 {
    field RxPBDlyTg0_r3 @0 {
       bits 7;
       access rw;
       reset 7'h0;
    }
  }
  register RxPBDlyTg1_r3 @'h369 {
    field RxPBDlyTg1_r3 @0 {
       bits 7;
       access rw;
       reset 7'h0;
    }
  }
  register RxPBDlyTg2_r3 @'h36a {
    field RxPBDlyTg2_r3 @0 {
       bits 7;
       access rw;
       reset 7'h0;
    }
  }
  register RxPBDlyTg3_r3 @'h36b {
    field RxPBDlyTg3_r3 @0 {
       bits 7;
       access rw;
       reset 7'h0;
    }
  }
  register Tsm0_i3 @'h3b2 {
    field RFU_Tsm0_i3 @0 {
       bits 14;
       access rw;
       reset 14'h0;
    }
  }
  register Tsm1_i3 @'h3b3 {
    field RFU_Tsm1_i3 @0 {
       bits 16;
       access ro;
       reset 16'h0;
    }
  }
  register Tsm2_i3 @'h3b4 {
    field RFU_Tsm2_i3 @0 {
       bits 1;
       access rw;
       reset 1'h0;
    }
  }
  register TxDqDlyTg0_r3_p0 @'h3c0 {
    field TxDqDlyTg0_r3_p0 @0 {
       bits 9;
       access rw;
       reset 9'h10;
    }
  }
  register TxDqDlyTg1_r3_p0 @'h3c1 {
    field TxDqDlyTg1_r3_p0 @0 {
       bits 9;
       access rw;
       reset 9'h10;
    }
  }
  register TxDqDlyTg2_r3_p0 @'h3c2 {
    field TxDqDlyTg2_r3_p0 @0 {
       bits 9;
       access rw;
       reset 9'h10;
    }
  }
  register TxDqDlyTg3_r3_p0 @'h3c3 {
    field TxDqDlyTg3_r3_p0 @0 {
       bits 9;
       access rw;
       reset 9'h10;
    }
  }
  register VrefDAC1_r4 @'h430 {
    field VrefDAC1_r4 @0 {
       bits 7;
       access rw;
       reset 7'h0;
    }
  }
  register TrainingCntr_r4 @'h432 {
    field RFU_TrainingCntr_r4 @0 {
       bits 16;
       access rw;
       reset 16'h0;
    }
  }
  register VrefDAC0_r4 @'h440 {
    field VrefDAC0_r4 @0 {
       bits 7;
       access rw;
       reset 7'h0;
    }
  }
  register TrainingIncDecDtsmEn_r4 @'h462 {
    field TrainingIncDecDtsmEn_r4 @0 {
       bits 9;
       access rw;
       reset 9'h0;
    }
  }
  register RxPBDlyTg0_r4 @'h468 {
    field RxPBDlyTg0_r4 @0 {
       bits 7;
       access rw;
       reset 7'h0;
    }
  }
  register RxPBDlyTg1_r4 @'h469 {
    field RxPBDlyTg1_r4 @0 {
       bits 7;
       access rw;
       reset 7'h0;
    }
  }
  register RxPBDlyTg2_r4 @'h46a {
    field RxPBDlyTg2_r4 @0 {
       bits 7;
       access rw;
       reset 7'h0;
    }
  }
  register RxPBDlyTg3_r4 @'h46b {
    field RxPBDlyTg3_r4 @0 {
       bits 7;
       access rw;
       reset 7'h0;
    }
  }
  register Tsm0_i4 @'h4b2 {
    field RFU_Tsm0_i4 @0 {
       bits 14;
       access rw;
       reset 14'h0;
    }
  }
  register Tsm1_i4 @'h4b3 {
    field RFU_Tsm1_i4 @0 {
       bits 16;
       access ro;
       reset 16'h0;
    }
  }
  register Tsm2_i4 @'h4b4 {
    field RFU_Tsm2_i4 @0 {
       bits 1;
       access rw;
       reset 1'h0;
    }
  }
  register TxDqDlyTg0_r4_p0 @'h4c0 {
    field TxDqDlyTg0_r4_p0 @0 {
       bits 9;
       access rw;
       reset 9'h10;
    }
  }
  register TxDqDlyTg1_r4_p0 @'h4c1 {
    field TxDqDlyTg1_r4_p0 @0 {
       bits 9;
       access rw;
       reset 9'h10;
    }
  }
  register TxDqDlyTg2_r4_p0 @'h4c2 {
    field TxDqDlyTg2_r4_p0 @0 {
       bits 9;
       access rw;
       reset 9'h10;
    }
  }
  register TxDqDlyTg3_r4_p0 @'h4c3 {
    field TxDqDlyTg3_r4_p0 @0 {
       bits 9;
       access rw;
       reset 9'h10;
    }
  }
  register VrefDAC1_r5 @'h530 {
    field VrefDAC1_r5 @0 {
       bits 7;
       access rw;
       reset 7'h0;
    }
  }
  register TrainingCntr_r5 @'h532 {
    field RFU_TrainingCntr_r5 @0 {
       bits 16;
       access rw;
       reset 16'h0;
    }
  }
  register VrefDAC0_r5 @'h540 {
    field VrefDAC0_r5 @0 {
       bits 7;
       access rw;
       reset 7'h0;
    }
  }
  register TrainingIncDecDtsmEn_r5 @'h562 {
    field TrainingIncDecDtsmEn_r5 @0 {
       bits 9;
       access rw;
       reset 9'h0;
    }
  }
  register RxPBDlyTg0_r5 @'h568 {
    field RxPBDlyTg0_r5 @0 {
       bits 7;
       access rw;
       reset 7'h0;
    }
  }
  register RxPBDlyTg1_r5 @'h569 {
    field RxPBDlyTg1_r5 @0 {
       bits 7;
       access rw;
       reset 7'h0;
    }
  }
  register RxPBDlyTg2_r5 @'h56a {
    field RxPBDlyTg2_r5 @0 {
       bits 7;
       access rw;
       reset 7'h0;
    }
  }
  register RxPBDlyTg3_r5 @'h56b {
    field RxPBDlyTg3_r5 @0 {
       bits 7;
       access rw;
       reset 7'h0;
    }
  }
  register Tsm0_i5 @'h5b2 {
    field RFU_Tsm0_i5 @0 {
       bits 14;
       access rw;
       reset 14'h0;
    }
  }
  register Tsm1_i5 @'h5b3 {
    field RFU_Tsm1_i5 @0 {
       bits 16;
       access ro;
       reset 16'h0;
    }
  }
  register Tsm2_i5 @'h5b4 {
    field RFU_Tsm2_i5 @0 {
       bits 1;
       access rw;
       reset 1'h0;
    }
  }
  register TxDqDlyTg0_r5_p0 @'h5c0 {
    field TxDqDlyTg0_r5_p0 @0 {
       bits 9;
       access rw;
       reset 9'h10;
    }
  }
  register TxDqDlyTg1_r5_p0 @'h5c1 {
    field TxDqDlyTg1_r5_p0 @0 {
       bits 9;
       access rw;
       reset 9'h10;
    }
  }
  register TxDqDlyTg2_r5_p0 @'h5c2 {
    field TxDqDlyTg2_r5_p0 @0 {
       bits 9;
       access rw;
       reset 9'h10;
    }
  }
  register TxDqDlyTg3_r5_p0 @'h5c3 {
    field TxDqDlyTg3_r5_p0 @0 {
       bits 9;
       access rw;
       reset 9'h10;
    }
  }
  register VrefDAC1_r6 @'h630 {
    field VrefDAC1_r6 @0 {
       bits 7;
       access rw;
       reset 7'h0;
    }
  }
  register TrainingCntr_r6 @'h632 {
    field RFU_TrainingCntr_r6 @0 {
       bits 16;
       access rw;
       reset 16'h0;
    }
  }
  register VrefDAC0_r6 @'h640 {
    field VrefDAC0_r6 @0 {
       bits 7;
       access rw;
       reset 7'h0;
    }
  }
  register TrainingIncDecDtsmEn_r6 @'h662 {
    field TrainingIncDecDtsmEn_r6 @0 {
       bits 9;
       access rw;
       reset 9'h0;
    }
  }
  register RxPBDlyTg0_r6 @'h668 {
    field RxPBDlyTg0_r6 @0 {
       bits 7;
       access rw;
       reset 7'h0;
    }
  }
  register RxPBDlyTg1_r6 @'h669 {
    field RxPBDlyTg1_r6 @0 {
       bits 7;
       access rw;
       reset 7'h0;
    }
  }
  register RxPBDlyTg2_r6 @'h66a {
    field RxPBDlyTg2_r6 @0 {
       bits 7;
       access rw;
       reset 7'h0;
    }
  }
  register RxPBDlyTg3_r6 @'h66b {
    field RxPBDlyTg3_r6 @0 {
       bits 7;
       access rw;
       reset 7'h0;
    }
  }
  register Tsm0_i6 @'h6b2 {
    field RFU_Tsm0_i6 @0 {
       bits 14;
       access rw;
       reset 14'h0;
    }
  }
  register Tsm1_i6 @'h6b3 {
    field RFU_Tsm1_i6 @0 {
       bits 16;
       access ro;
       reset 16'h0;
    }
  }
  register Tsm2_i6 @'h6b4 {
    field RFU_Tsm2_i6 @0 {
       bits 1;
       access rw;
       reset 1'h0;
    }
  }
  register TxDqDlyTg0_r6_p0 @'h6c0 {
    field TxDqDlyTg0_r6_p0 @0 {
       bits 9;
       access rw;
       reset 9'h10;
    }
  }
  register TxDqDlyTg1_r6_p0 @'h6c1 {
    field TxDqDlyTg1_r6_p0 @0 {
       bits 9;
       access rw;
       reset 9'h10;
    }
  }
  register TxDqDlyTg2_r6_p0 @'h6c2 {
    field TxDqDlyTg2_r6_p0 @0 {
       bits 9;
       access rw;
       reset 9'h10;
    }
  }
  register TxDqDlyTg3_r6_p0 @'h6c3 {
    field TxDqDlyTg3_r6_p0 @0 {
       bits 9;
       access rw;
       reset 9'h10;
    }
  }
  register VrefDAC1_r7 @'h730 {
    field VrefDAC1_r7 @0 {
       bits 7;
       access rw;
       reset 7'h0;
    }
  }
  register TrainingCntr_r7 @'h732 {
    field RFU_TrainingCntr_r7 @0 {
       bits 16;
       access rw;
       reset 16'h0;
    }
  }
  register VrefDAC0_r7 @'h740 {
    field VrefDAC0_r7 @0 {
       bits 7;
       access rw;
       reset 7'h0;
    }
  }
  register TrainingIncDecDtsmEn_r7 @'h762 {
    field TrainingIncDecDtsmEn_r7 @0 {
       bits 9;
       access rw;
       reset 9'h0;
    }
  }
  register RxPBDlyTg0_r7 @'h768 {
    field RxPBDlyTg0_r7 @0 {
       bits 7;
       access rw;
       reset 7'h0;
    }
  }
  register RxPBDlyTg1_r7 @'h769 {
    field RxPBDlyTg1_r7 @0 {
       bits 7;
       access rw;
       reset 7'h0;
    }
  }
  register RxPBDlyTg2_r7 @'h76a {
    field RxPBDlyTg2_r7 @0 {
       bits 7;
       access rw;
       reset 7'h0;
    }
  }
  register RxPBDlyTg3_r7 @'h76b {
    field RxPBDlyTg3_r7 @0 {
       bits 7;
       access rw;
       reset 7'h0;
    }
  }
  register Tsm0_i7 @'h7b2 {
    field RFU_Tsm0_i7 @0 {
       bits 14;
       access rw;
       reset 14'h0;
    }
  }
  register Tsm1_i7 @'h7b3 {
    field RFU_Tsm1_i7 @0 {
       bits 16;
       access ro;
       reset 16'h0;
    }
  }
  register Tsm2_i7 @'h7b4 {
    field RFU_Tsm2_i7 @0 {
       bits 1;
       access rw;
       reset 1'h0;
    }
  }
  register TxDqDlyTg0_r7_p0 @'h7c0 {
    field TxDqDlyTg0_r7_p0 @0 {
       bits 9;
       access rw;
       reset 9'h10;
    }
  }
  register TxDqDlyTg1_r7_p0 @'h7c1 {
    field TxDqDlyTg1_r7_p0 @0 {
       bits 9;
       access rw;
       reset 9'h10;
    }
  }
  register TxDqDlyTg2_r7_p0 @'h7c2 {
    field TxDqDlyTg2_r7_p0 @0 {
       bits 9;
       access rw;
       reset 9'h10;
    }
  }
  register TxDqDlyTg3_r7_p0 @'h7c3 {
    field TxDqDlyTg3_r7_p0 @0 {
       bits 9;
       access rw;
       reset 9'h10;
    }
  }
  register VrefDAC1_r8 @'h830 {
    field VrefDAC1_r8 @0 {
       bits 7;
       access rw;
       reset 7'h0;
    }
  }
  register TrainingCntr_r8 @'h832 {
    field RFU_TrainingCntr_r8 @0 {
       bits 16;
       access rw;
       reset 16'h0;
    }
  }
  register VrefDAC0_r8 @'h840 {
    field VrefDAC0_r8 @0 {
       bits 7;
       access rw;
       reset 7'h0;
    }
  }
  register TrainingIncDecDtsmEn_r8 @'h862 {
    field TrainingIncDecDtsmEn_r8 @0 {
       bits 9;
       access rw;
       reset 9'h0;
    }
  }
  register RxPBDlyTg0_r8 @'h868 {
    field RxPBDlyTg0_r8 @0 {
       bits 7;
       access rw;
       reset 7'h0;
    }
  }
  register RxPBDlyTg1_r8 @'h869 {
    field RxPBDlyTg1_r8 @0 {
       bits 7;
       access rw;
       reset 7'h0;
    }
  }
  register RxPBDlyTg2_r8 @'h86a {
    field RxPBDlyTg2_r8 @0 {
       bits 7;
       access rw;
       reset 7'h0;
    }
  }
  register RxPBDlyTg3_r8 @'h86b {
    field RxPBDlyTg3_r8 @0 {
       bits 7;
       access rw;
       reset 7'h0;
    }
  }
  register Tsm0_i8 @'h8b2 {
    field RFU_Tsm0_i8 @0 {
       bits 14;
       access rw;
       reset 14'h0;
    }
  }
  register Tsm1_i8 @'h8b3 {
    field RFU_Tsm1_i8 @0 {
       bits 16;
       access ro;
       reset 16'h0;
    }
  }
  register Tsm2_i8 @'h8b4 {
    field RFU_Tsm2_i8 @0 {
       bits 1;
       access rw;
       reset 1'h0;
    }
  }
  register TxDqDlyTg0_r8_p0 @'h8c0 {
    field TxDqDlyTg0_r8_p0 @0 {
       bits 9;
       access rw;
       reset 9'h10;
    }
  }
  register TxDqDlyTg1_r8_p0 @'h8c1 {
    field TxDqDlyTg1_r8_p0 @0 {
       bits 9;
       access rw;
       reset 9'h10;
    }
  }
  register TxDqDlyTg2_r8_p0 @'h8c2 {
    field TxDqDlyTg2_r8_p0 @0 {
       bits 9;
       access rw;
       reset 9'h10;
    }
  }
  register TxDqDlyTg3_r8_p0 @'h8c3 {
    field TxDqDlyTg3_r8_p0 @0 {
       bits 9;
       access rw;
       reset 9'h10;
    }
  }
  register UseDqsEnReplica_p1 @'h100003 {
    field UseDqsEnReplica_p1 @0 {
       bits 1;
       access rw;
       reset 1'h0;
    }
  }
  register DFIMRL_p1 @'h100020 {
    field DFIMRL_p1 @0 {
       bits 5;
       access rw;
       reset 5'h6;
    }
  }
  register TxImpedanceCtrl0_b0_p1 @'h100041 {
    field DrvStrenDqP @0 {
       bits 6;
       access rw;
       reset 6'h3f;
    }
    field DrvStrenDqN @6 {
       bits 6;
       access rw;
       reset 6'h3f;
    }
  }
  register DqDqsRcvCntrl_b0_p1 @'h100043 {
    field SelAnalogVref @0 {
       bits 1;
       access rw;
       reset 1'h0;
    }
    field ExtVrefRange @1 {
       bits 1;
       access rw;
       reset 1'h0;
    }
    field DfeCtrl @2 {
       bits 2;
       access rw;
       reset 2'h0;
    }
    field MajorModeDbyte @4 {
       bits 3;
       access rw;
       reset 3'h3;
    }
    field GainCurrAdj @7 {
       bits 5;
       access rw;
       reset 5'hb;
    }
    field Reserved @12 {
       bits 4;
    }
  }
  register TxEqualizationMode_p1 @'h100048 {
    field TxEqMode @0 {
       bits 2;
       access rw;
       reset 2'h0;
    }
  }
  register TxImpedanceCtrl1_b0_p1 @'h100049 {
    field DrvStrenFSDqP @0 {
       bits 6;
       access rw;
       reset 6'h3f;
    }
    field DrvStrenFSDqN @6 {
       bits 6;
       access rw;
       reset 6'h3f;
    }
  }
  register TxImpedanceCtrl2_b0_p1 @'h10004b {
    field DrvStrenEQHiDqP @0 {
       bits 6;
       access rw;
       reset 6'h0;
    }
    field DrvStrenEQLoDqN @6 {
       bits 6;
       access rw;
       reset 6'h0;
    }
  }
  register DqDqsRcvCntrl2_p1 @'h10004c {
    field EnRxAgressivePDR @0 {
       bits 1;
       access rw;
       reset 1'h0;
    }
  }
  register TxOdtDrvStren_b0_p1 @'h10004d {
    field ODTStrenP @0 {
       bits 6;
       access rw;
       reset 6'h0;
    }
    field ODTStrenN @6 {
       bits 6;
       access rw;
       reset 6'h0;
    }
  }
  register TxSlewRate_b0_p1 @'h10005f {
    field TxPreP @0 {
       bits 4;
       access rw;
       reset 4'hf;
    }
    field TxPreN @4 {
       bits 4;
       access rw;
       reset 4'hf;
    }
    field TxPreDrvMode @8 {
       bits 3;
       access rw;
       reset 3'h7;
    }
  }
  register RxEnDlyTg0_u0_p1 @'h100080 {
    field RxEnDlyTg0_u0_p1 @0 {
       bits 11;
       access rw;
       reset 11'h100;
    }
  }
  register RxEnDlyTg1_u0_p1 @'h100081 {
    field RxEnDlyTg1_u0_p1 @0 {
       bits 11;
       access rw;
       reset 11'h100;
    }
  }
  register RxEnDlyTg2_u0_p1 @'h100082 {
    field RxEnDlyTg2_u0_p1 @0 {
       bits 11;
       access rw;
       reset 11'h100;
    }
  }
  register RxEnDlyTg3_u0_p1 @'h100083 {
    field RxEnDlyTg3_u0_p1 @0 {
       bits 11;
       access rw;
       reset 11'h100;
    }
  }
  register RxClkDlyTg0_u0_p1 @'h10008c {
    field RxClkDlyTg0_u0_p1 @0 {
       bits 6;
       access rw;
       reset 6'h10;
    }
  }
  register RxClkDlyTg1_u0_p1 @'h10008d {
    field RxClkDlyTg1_u0_p1 @0 {
       bits 6;
       access rw;
       reset 6'h10;
    }
  }
  register RxClkDlyTg2_u0_p1 @'h10008e {
    field RxClkDlyTg2_u0_p1 @0 {
       bits 6;
       access rw;
       reset 6'h10;
    }
  }
  register RxClkDlyTg3_u0_p1 @'h10008f {
    field RxClkDlyTg3_u0_p1 @0 {
       bits 6;
       access rw;
       reset 6'h10;
    }
  }
  register RxClkcDlyTg0_u0_p1 @'h100090 {
    field RxClkcDlyTg0_u0_p1 @0 {
       bits 6;
       access rw;
       reset 6'h10;
    }
  }
  register RxClkcDlyTg1_u0_p1 @'h100091 {
    field RxClkcDlyTg1_u0_p1 @0 {
       bits 6;
       access rw;
       reset 6'h10;
    }
  }
  register RxClkcDlyTg2_u0_p1 @'h100092 {
    field RxClkcDlyTg2_u0_p1 @0 {
       bits 6;
       access rw;
       reset 6'h10;
    }
  }
  register RxClkcDlyTg3_u0_p1 @'h100093 {
    field RxClkcDlyTg3_u0_p1 @0 {
       bits 6;
       access rw;
       reset 6'h10;
    }
  }
  register PptDqsCntInvTrnTg0_p1 @'h1000ae {
    field PptDqsCntInvTrnTg0_p1 @0 {
       bits 16;
       access rw;
       reset 16'h0;
    }
  }
  register PptDqsCntInvTrnTg1_p1 @'h1000af {
    field PptDqsCntInvTrnTg1_p1 @0 {
       bits 16;
       access rw;
       reset 16'h0;
    }
  }
  register TxDqDlyTg0_r0_p1 @'h1000c0 {
    field TxDqDlyTg0_r0_p1 @0 {
       bits 9;
       access rw;
       reset 9'h10;
    }
  }
  register TxDqDlyTg1_r0_p1 @'h1000c1 {
    field TxDqDlyTg1_r0_p1 @0 {
       bits 9;
       access rw;
       reset 9'h10;
    }
  }
  register TxDqDlyTg2_r0_p1 @'h1000c2 {
    field TxDqDlyTg2_r0_p1 @0 {
       bits 9;
       access rw;
       reset 9'h10;
    }
  }
  register TxDqDlyTg3_r0_p1 @'h1000c3 {
    field TxDqDlyTg3_r0_p1 @0 {
       bits 9;
       access rw;
       reset 9'h10;
    }
  }
  register TxDqsDlyTg0_u0_p1 @'h1000d0 {
    field TxDqsDlyTg0_u0_p1 @0 {
       bits 10;
       access rw;
       reset 10'h100;
    }
  }
  register TxDqsDlyTg1_u0_p1 @'h1000d1 {
    field TxDqsDlyTg1_u0_p1 @0 {
       bits 10;
       access rw;
       reset 10'h100;
    }
  }
  register TxDqsDlyTg2_u0_p1 @'h1000d2 {
    field TxDqsDlyTg2_u0_p1 @0 {
       bits 10;
       access rw;
       reset 10'h100;
    }
  }
  register TxDqsDlyTg3_u0_p1 @'h1000d3 {
    field TxDqsDlyTg3_u0_p1 @0 {
       bits 10;
       access rw;
       reset 10'h100;
    }
  }
  register TxImpedanceCtrl0_b1_p1 @'h100141 {
    field DrvStrenDqP @0 {
       bits 6;
       access rw;
       reset 6'h3f;
    }
    field DrvStrenDqN @6 {
       bits 6;
       access rw;
       reset 6'h3f;
    }
  }
  register DqDqsRcvCntrl_b1_p1 @'h100143 {
    field SelAnalogVref @0 {
       bits 1;
       access rw;
       reset 1'h0;
    }
    field ExtVrefRange @1 {
       bits 1;
       access rw;
       reset 1'h0;
    }
    field DfeCtrl @2 {
       bits 2;
       access rw;
       reset 2'h0;
    }
    field MajorModeDbyte @4 {
       bits 3;
       access rw;
       reset 3'h3;
    }
    field GainCurrAdj @7 {
       bits 5;
       access rw;
       reset 5'hb;
    }
    field Reserved @12 {
       bits 4;
    }
  }
  register TxImpedanceCtrl1_b1_p1 @'h100149 {
    field DrvStrenFSDqP @0 {
       bits 6;
       access rw;
       reset 6'h3f;
    }
    field DrvStrenFSDqN @6 {
       bits 6;
       access rw;
       reset 6'h3f;
    }
  }
  register TxImpedanceCtrl2_b1_p1 @'h10014b {
    field DrvStrenEQHiDqP @0 {
       bits 6;
       access rw;
       reset 6'h0;
    }
    field DrvStrenEQLoDqN @6 {
       bits 6;
       access rw;
       reset 6'h0;
    }
  }
  register TxOdtDrvStren_b1_p1 @'h10014d {
    field ODTStrenP @0 {
       bits 6;
       access rw;
       reset 6'h0;
    }
    field ODTStrenN @6 {
       bits 6;
       access rw;
       reset 6'h0;
    }
  }
  register TxSlewRate_b1_p1 @'h10015f {
    field TxPreP @0 {
       bits 4;
       access rw;
       reset 4'hf;
    }
    field TxPreN @4 {
       bits 4;
       access rw;
       reset 4'hf;
    }
    field TxPreDrvMode @8 {
       bits 3;
       access rw;
       reset 3'h7;
    }
  }
  register RxEnDlyTg0_u1_p1 @'h100180 {
    field RxEnDlyTg0_u1_p1 @0 {
       bits 11;
       access rw;
       reset 11'h100;
    }
  }
  register RxEnDlyTg1_u1_p1 @'h100181 {
    field RxEnDlyTg1_u1_p1 @0 {
       bits 11;
       access rw;
       reset 11'h100;
    }
  }
  register RxEnDlyTg2_u1_p1 @'h100182 {
    field RxEnDlyTg2_u1_p1 @0 {
       bits 11;
       access rw;
       reset 11'h100;
    }
  }
  register RxEnDlyTg3_u1_p1 @'h100183 {
    field RxEnDlyTg3_u1_p1 @0 {
       bits 11;
       access rw;
       reset 11'h100;
    }
  }
  register RxClkDlyTg0_u1_p1 @'h10018c {
    field RxClkDlyTg0_u1_p1 @0 {
       bits 6;
       access rw;
       reset 6'h10;
    }
  }
  register RxClkDlyTg1_u1_p1 @'h10018d {
    field RxClkDlyTg1_u1_p1 @0 {
       bits 6;
       access rw;
       reset 6'h10;
    }
  }
  register RxClkDlyTg2_u1_p1 @'h10018e {
    field RxClkDlyTg2_u1_p1 @0 {
       bits 6;
       access rw;
       reset 6'h10;
    }
  }
  register RxClkDlyTg3_u1_p1 @'h10018f {
    field RxClkDlyTg3_u1_p1 @0 {
       bits 6;
       access rw;
       reset 6'h10;
    }
  }
  register RxClkcDlyTg0_u1_p1 @'h100190 {
    field RxClkcDlyTg0_u1_p1 @0 {
       bits 6;
       access rw;
       reset 6'h10;
    }
  }
  register RxClkcDlyTg1_u1_p1 @'h100191 {
    field RxClkcDlyTg1_u1_p1 @0 {
       bits 6;
       access rw;
       reset 6'h10;
    }
  }
  register RxClkcDlyTg2_u1_p1 @'h100192 {
    field RxClkcDlyTg2_u1_p1 @0 {
       bits 6;
       access rw;
       reset 6'h10;
    }
  }
  register RxClkcDlyTg3_u1_p1 @'h100193 {
    field RxClkcDlyTg3_u1_p1 @0 {
       bits 6;
       access rw;
       reset 6'h10;
    }
  }
  register TxDqDlyTg0_r1_p1 @'h1001c0 {
    field TxDqDlyTg0_r1_p1 @0 {
       bits 9;
       access rw;
       reset 9'h10;
    }
  }
  register TxDqDlyTg1_r1_p1 @'h1001c1 {
    field TxDqDlyTg1_r1_p1 @0 {
       bits 9;
       access rw;
       reset 9'h10;
    }
  }
  register TxDqDlyTg2_r1_p1 @'h1001c2 {
    field TxDqDlyTg2_r1_p1 @0 {
       bits 9;
       access rw;
       reset 9'h10;
    }
  }
  register TxDqDlyTg3_r1_p1 @'h1001c3 {
    field TxDqDlyTg3_r1_p1 @0 {
       bits 9;
       access rw;
       reset 9'h10;
    }
  }
  register TxDqsDlyTg0_u1_p1 @'h1001d0 {
    field TxDqsDlyTg0_u1_p1 @0 {
       bits 10;
       access rw;
       reset 10'h100;
    }
  }
  register TxDqsDlyTg1_u1_p1 @'h1001d1 {
    field TxDqsDlyTg1_u1_p1 @0 {
       bits 10;
       access rw;
       reset 10'h100;
    }
  }
  register TxDqsDlyTg2_u1_p1 @'h1001d2 {
    field TxDqsDlyTg2_u1_p1 @0 {
       bits 10;
       access rw;
       reset 10'h100;
    }
  }
  register TxDqsDlyTg3_u1_p1 @'h1001d3 {
    field TxDqsDlyTg3_u1_p1 @0 {
       bits 10;
       access rw;
       reset 10'h100;
    }
  }
  register TxDqDlyTg0_r2_p1 @'h1002c0 {
    field TxDqDlyTg0_r2_p1 @0 {
       bits 9;
       access rw;
       reset 9'h10;
    }
  }
  register TxDqDlyTg1_r2_p1 @'h1002c1 {
    field TxDqDlyTg1_r2_p1 @0 {
       bits 9;
       access rw;
       reset 9'h10;
    }
  }
  register TxDqDlyTg2_r2_p1 @'h1002c2 {
    field TxDqDlyTg2_r2_p1 @0 {
       bits 9;
       access rw;
       reset 9'h10;
    }
  }
  register TxDqDlyTg3_r2_p1 @'h1002c3 {
    field TxDqDlyTg3_r2_p1 @0 {
       bits 9;
       access rw;
       reset 9'h10;
    }
  }
  register TxDqDlyTg0_r3_p1 @'h1003c0 {
    field TxDqDlyTg0_r3_p1 @0 {
       bits 9;
       access rw;
       reset 9'h10;
    }
  }
  register TxDqDlyTg1_r3_p1 @'h1003c1 {
    field TxDqDlyTg1_r3_p1 @0 {
       bits 9;
       access rw;
       reset 9'h10;
    }
  }
  register TxDqDlyTg2_r3_p1 @'h1003c2 {
    field TxDqDlyTg2_r3_p1 @0 {
       bits 9;
       access rw;
       reset 9'h10;
    }
  }
  register TxDqDlyTg3_r3_p1 @'h1003c3 {
    field TxDqDlyTg3_r3_p1 @0 {
       bits 9;
       access rw;
       reset 9'h10;
    }
  }
  register TxDqDlyTg0_r4_p1 @'h1004c0 {
    field TxDqDlyTg0_r4_p1 @0 {
       bits 9;
       access rw;
       reset 9'h10;
    }
  }
  register TxDqDlyTg1_r4_p1 @'h1004c1 {
    field TxDqDlyTg1_r4_p1 @0 {
       bits 9;
       access rw;
       reset 9'h10;
    }
  }
  register TxDqDlyTg2_r4_p1 @'h1004c2 {
    field TxDqDlyTg2_r4_p1 @0 {
       bits 9;
       access rw;
       reset 9'h10;
    }
  }
  register TxDqDlyTg3_r4_p1 @'h1004c3 {
    field TxDqDlyTg3_r4_p1 @0 {
       bits 9;
       access rw;
       reset 9'h10;
    }
  }
  register TxDqDlyTg0_r5_p1 @'h1005c0 {
    field TxDqDlyTg0_r5_p1 @0 {
       bits 9;
       access rw;
       reset 9'h10;
    }
  }
  register TxDqDlyTg1_r5_p1 @'h1005c1 {
    field TxDqDlyTg1_r5_p1 @0 {
       bits 9;
       access rw;
       reset 9'h10;
    }
  }
  register TxDqDlyTg2_r5_p1 @'h1005c2 {
    field TxDqDlyTg2_r5_p1 @0 {
       bits 9;
       access rw;
       reset 9'h10;
    }
  }
  register TxDqDlyTg3_r5_p1 @'h1005c3 {
    field TxDqDlyTg3_r5_p1 @0 {
       bits 9;
       access rw;
       reset 9'h10;
    }
  }
  register TxDqDlyTg0_r6_p1 @'h1006c0 {
    field TxDqDlyTg0_r6_p1 @0 {
       bits 9;
       access rw;
       reset 9'h10;
    }
  }
  register TxDqDlyTg1_r6_p1 @'h1006c1 {
    field TxDqDlyTg1_r6_p1 @0 {
       bits 9;
       access rw;
       reset 9'h10;
    }
  }
  register TxDqDlyTg2_r6_p1 @'h1006c2 {
    field TxDqDlyTg2_r6_p1 @0 {
       bits 9;
       access rw;
       reset 9'h10;
    }
  }
  register TxDqDlyTg3_r6_p1 @'h1006c3 {
    field TxDqDlyTg3_r6_p1 @0 {
       bits 9;
       access rw;
       reset 9'h10;
    }
  }
  register TxDqDlyTg0_r7_p1 @'h1007c0 {
    field TxDqDlyTg0_r7_p1 @0 {
       bits 9;
       access rw;
       reset 9'h10;
    }
  }
  register TxDqDlyTg1_r7_p1 @'h1007c1 {
    field TxDqDlyTg1_r7_p1 @0 {
       bits 9;
       access rw;
       reset 9'h10;
    }
  }
  register TxDqDlyTg2_r7_p1 @'h1007c2 {
    field TxDqDlyTg2_r7_p1 @0 {
       bits 9;
       access rw;
       reset 9'h10;
    }
  }
  register TxDqDlyTg3_r7_p1 @'h1007c3 {
    field TxDqDlyTg3_r7_p1 @0 {
       bits 9;
       access rw;
       reset 9'h10;
    }
  }
  register TxDqDlyTg0_r8_p1 @'h1008c0 {
    field TxDqDlyTg0_r8_p1 @0 {
       bits 9;
       access rw;
       reset 9'h10;
    }
  }
  register TxDqDlyTg1_r8_p1 @'h1008c1 {
    field TxDqDlyTg1_r8_p1 @0 {
       bits 9;
       access rw;
       reset 9'h10;
    }
  }
  register TxDqDlyTg2_r8_p1 @'h1008c2 {
    field TxDqDlyTg2_r8_p1 @0 {
       bits 9;
       access rw;
       reset 9'h10;
    }
  }
  register TxDqDlyTg3_r8_p1 @'h1008c3 {
    field TxDqDlyTg3_r8_p1 @0 {
       bits 9;
       access rw;
       reset 9'h10;
    }
  }
  register UseDqsEnReplica_p2 @'h200003 {
    field UseDqsEnReplica_p2 @0 {
       bits 1;
       access rw;
       reset 1'h0;
    }
  }
  register DFIMRL_p2 @'h200020 {
    field DFIMRL_p2 @0 {
       bits 5;
       access rw;
       reset 5'h6;
    }
  }
  register TxImpedanceCtrl0_b0_p2 @'h200041 {
    field DrvStrenDqP @0 {
       bits 6;
       access rw;
       reset 6'h3f;
    }
    field DrvStrenDqN @6 {
       bits 6;
       access rw;
       reset 6'h3f;
    }
  }
  register DqDqsRcvCntrl_b0_p2 @'h200043 {
    field SelAnalogVref @0 {
       bits 1;
       access rw;
       reset 1'h0;
    }
    field ExtVrefRange @1 {
       bits 1;
       access rw;
       reset 1'h0;
    }
    field DfeCtrl @2 {
       bits 2;
       access rw;
       reset 2'h0;
    }
    field MajorModeDbyte @4 {
       bits 3;
       access rw;
       reset 3'h3;
    }
    field GainCurrAdj @7 {
       bits 5;
       access rw;
       reset 5'hb;
    }
    field Reserved @12 {
       bits 4;
    }
  }
  register TxEqualizationMode_p2 @'h200048 {
    field TxEqMode @0 {
       bits 2;
       access rw;
       reset 2'h0;
    }
  }
  register TxImpedanceCtrl1_b0_p2 @'h200049 {
    field DrvStrenFSDqP @0 {
       bits 6;
       access rw;
       reset 6'h3f;
    }
    field DrvStrenFSDqN @6 {
       bits 6;
       access rw;
       reset 6'h3f;
    }
  }
  register TxImpedanceCtrl2_b0_p2 @'h20004b {
    field DrvStrenEQHiDqP @0 {
       bits 6;
       access rw;
       reset 6'h0;
    }
    field DrvStrenEQLoDqN @6 {
       bits 6;
       access rw;
       reset 6'h0;
    }
  }
  register DqDqsRcvCntrl2_p2 @'h20004c {
    field EnRxAgressivePDR @0 {
       bits 1;
       access rw;
       reset 1'h0;
    }
  }
  register TxOdtDrvStren_b0_p2 @'h20004d {
    field ODTStrenP @0 {
       bits 6;
       access rw;
       reset 6'h0;
    }
    field ODTStrenN @6 {
       bits 6;
       access rw;
       reset 6'h0;
    }
  }
  register TxSlewRate_b0_p2 @'h20005f {
    field TxPreP @0 {
       bits 4;
       access rw;
       reset 4'hf;
    }
    field TxPreN @4 {
       bits 4;
       access rw;
       reset 4'hf;
    }
    field TxPreDrvMode @8 {
       bits 3;
       access rw;
       reset 3'h7;
    }
  }
  register RxEnDlyTg0_u0_p2 @'h200080 {
    field RxEnDlyTg0_u0_p2 @0 {
       bits 11;
       access rw;
       reset 11'h100;
    }
  }
  register RxEnDlyTg1_u0_p2 @'h200081 {
    field RxEnDlyTg1_u0_p2 @0 {
       bits 11;
       access rw;
       reset 11'h100;
    }
  }
  register RxEnDlyTg2_u0_p2 @'h200082 {
    field RxEnDlyTg2_u0_p2 @0 {
       bits 11;
       access rw;
       reset 11'h100;
    }
  }
  register RxEnDlyTg3_u0_p2 @'h200083 {
    field RxEnDlyTg3_u0_p2 @0 {
       bits 11;
       access rw;
       reset 11'h100;
    }
  }
  register RxClkDlyTg0_u0_p2 @'h20008c {
    field RxClkDlyTg0_u0_p2 @0 {
       bits 6;
       access rw;
       reset 6'h10;
    }
  }
  register RxClkDlyTg1_u0_p2 @'h20008d {
    field RxClkDlyTg1_u0_p2 @0 {
       bits 6;
       access rw;
       reset 6'h10;
    }
  }
  register RxClkDlyTg2_u0_p2 @'h20008e {
    field RxClkDlyTg2_u0_p2 @0 {
       bits 6;
       access rw;
       reset 6'h10;
    }
  }
  register RxClkDlyTg3_u0_p2 @'h20008f {
    field RxClkDlyTg3_u0_p2 @0 {
       bits 6;
       access rw;
       reset 6'h10;
    }
  }
  register RxClkcDlyTg0_u0_p2 @'h200090 {
    field RxClkcDlyTg0_u0_p2 @0 {
       bits 6;
       access rw;
       reset 6'h10;
    }
  }
  register RxClkcDlyTg1_u0_p2 @'h200091 {
    field RxClkcDlyTg1_u0_p2 @0 {
       bits 6;
       access rw;
       reset 6'h10;
    }
  }
  register RxClkcDlyTg2_u0_p2 @'h200092 {
    field RxClkcDlyTg2_u0_p2 @0 {
       bits 6;
       access rw;
       reset 6'h10;
    }
  }
  register RxClkcDlyTg3_u0_p2 @'h200093 {
    field RxClkcDlyTg3_u0_p2 @0 {
       bits 6;
       access rw;
       reset 6'h10;
    }
  }
  register PptDqsCntInvTrnTg0_p2 @'h2000ae {
    field PptDqsCntInvTrnTg0_p2 @0 {
       bits 16;
       access rw;
       reset 16'h0;
    }
  }
  register PptDqsCntInvTrnTg1_p2 @'h2000af {
    field PptDqsCntInvTrnTg1_p2 @0 {
       bits 16;
       access rw;
       reset 16'h0;
    }
  }
  register TxDqDlyTg0_r0_p2 @'h2000c0 {
    field TxDqDlyTg0_r0_p2 @0 {
       bits 9;
       access rw;
       reset 9'h10;
    }
  }
  register TxDqDlyTg1_r0_p2 @'h2000c1 {
    field TxDqDlyTg1_r0_p2 @0 {
       bits 9;
       access rw;
       reset 9'h10;
    }
  }
  register TxDqDlyTg2_r0_p2 @'h2000c2 {
    field TxDqDlyTg2_r0_p2 @0 {
       bits 9;
       access rw;
       reset 9'h10;
    }
  }
  register TxDqDlyTg3_r0_p2 @'h2000c3 {
    field TxDqDlyTg3_r0_p2 @0 {
       bits 9;
       access rw;
       reset 9'h10;
    }
  }
  register TxDqsDlyTg0_u0_p2 @'h2000d0 {
    field TxDqsDlyTg0_u0_p2 @0 {
       bits 10;
       access rw;
       reset 10'h100;
    }
  }
  register TxDqsDlyTg1_u0_p2 @'h2000d1 {
    field TxDqsDlyTg1_u0_p2 @0 {
       bits 10;
       access rw;
       reset 10'h100;
    }
  }
  register TxDqsDlyTg2_u0_p2 @'h2000d2 {
    field TxDqsDlyTg2_u0_p2 @0 {
       bits 10;
       access rw;
       reset 10'h100;
    }
  }
  register TxDqsDlyTg3_u0_p2 @'h2000d3 {
    field TxDqsDlyTg3_u0_p2 @0 {
       bits 10;
       access rw;
       reset 10'h100;
    }
  }
  register TxImpedanceCtrl0_b1_p2 @'h200141 {
    field DrvStrenDqP @0 {
       bits 6;
       access rw;
       reset 6'h3f;
    }
    field DrvStrenDqN @6 {
       bits 6;
       access rw;
       reset 6'h3f;
    }
  }
  register DqDqsRcvCntrl_b1_p2 @'h200143 {
    field SelAnalogVref @0 {
       bits 1;
       access rw;
       reset 1'h0;
    }
    field ExtVrefRange @1 {
       bits 1;
       access rw;
       reset 1'h0;
    }
    field DfeCtrl @2 {
       bits 2;
       access rw;
       reset 2'h0;
    }
    field MajorModeDbyte @4 {
       bits 3;
       access rw;
       reset 3'h3;
    }
    field GainCurrAdj @7 {
       bits 5;
       access rw;
       reset 5'hb;
    }
    field Reserved @12 {
       bits 4;
    }
  }
  register TxImpedanceCtrl1_b1_p2 @'h200149 {
    field DrvStrenFSDqP @0 {
       bits 6;
       access rw;
       reset 6'h3f;
    }
    field DrvStrenFSDqN @6 {
       bits 6;
       access rw;
       reset 6'h3f;
    }
  }
  register TxImpedanceCtrl2_b1_p2 @'h20014b {
    field DrvStrenEQHiDqP @0 {
       bits 6;
       access rw;
       reset 6'h0;
    }
    field DrvStrenEQLoDqN @6 {
       bits 6;
       access rw;
       reset 6'h0;
    }
  }
  register TxOdtDrvStren_b1_p2 @'h20014d {
    field ODTStrenP @0 {
       bits 6;
       access rw;
       reset 6'h0;
    }
    field ODTStrenN @6 {
       bits 6;
       access rw;
       reset 6'h0;
    }
  }
  register TxSlewRate_b1_p2 @'h20015f {
    field TxPreP @0 {
       bits 4;
       access rw;
       reset 4'hf;
    }
    field TxPreN @4 {
       bits 4;
       access rw;
       reset 4'hf;
    }
    field TxPreDrvMode @8 {
       bits 3;
       access rw;
       reset 3'h7;
    }
  }
  register RxEnDlyTg0_u1_p2 @'h200180 {
    field RxEnDlyTg0_u1_p2 @0 {
       bits 11;
       access rw;
       reset 11'h100;
    }
  }
  register RxEnDlyTg1_u1_p2 @'h200181 {
    field RxEnDlyTg1_u1_p2 @0 {
       bits 11;
       access rw;
       reset 11'h100;
    }
  }
  register RxEnDlyTg2_u1_p2 @'h200182 {
    field RxEnDlyTg2_u1_p2 @0 {
       bits 11;
       access rw;
       reset 11'h100;
    }
  }
  register RxEnDlyTg3_u1_p2 @'h200183 {
    field RxEnDlyTg3_u1_p2 @0 {
       bits 11;
       access rw;
       reset 11'h100;
    }
  }
  register RxClkDlyTg0_u1_p2 @'h20018c {
    field RxClkDlyTg0_u1_p2 @0 {
       bits 6;
       access rw;
       reset 6'h10;
    }
  }
  register RxClkDlyTg1_u1_p2 @'h20018d {
    field RxClkDlyTg1_u1_p2 @0 {
       bits 6;
       access rw;
       reset 6'h10;
    }
  }
  register RxClkDlyTg2_u1_p2 @'h20018e {
    field RxClkDlyTg2_u1_p2 @0 {
       bits 6;
       access rw;
       reset 6'h10;
    }
  }
  register RxClkDlyTg3_u1_p2 @'h20018f {
    field RxClkDlyTg3_u1_p2 @0 {
       bits 6;
       access rw;
       reset 6'h10;
    }
  }
  register RxClkcDlyTg0_u1_p2 @'h200190 {
    field RxClkcDlyTg0_u1_p2 @0 {
       bits 6;
       access rw;
       reset 6'h10;
    }
  }
  register RxClkcDlyTg1_u1_p2 @'h200191 {
    field RxClkcDlyTg1_u1_p2 @0 {
       bits 6;
       access rw;
       reset 6'h10;
    }
  }
  register RxClkcDlyTg2_u1_p2 @'h200192 {
    field RxClkcDlyTg2_u1_p2 @0 {
       bits 6;
       access rw;
       reset 6'h10;
    }
  }
  register RxClkcDlyTg3_u1_p2 @'h200193 {
    field RxClkcDlyTg3_u1_p2 @0 {
       bits 6;
       access rw;
       reset 6'h10;
    }
  }
  register TxDqDlyTg0_r1_p2 @'h2001c0 {
    field TxDqDlyTg0_r1_p2 @0 {
       bits 9;
       access rw;
       reset 9'h10;
    }
  }
  register TxDqDlyTg1_r1_p2 @'h2001c1 {
    field TxDqDlyTg1_r1_p2 @0 {
       bits 9;
       access rw;
       reset 9'h10;
    }
  }
  register TxDqDlyTg2_r1_p2 @'h2001c2 {
    field TxDqDlyTg2_r1_p2 @0 {
       bits 9;
       access rw;
       reset 9'h10;
    }
  }
  register TxDqDlyTg3_r1_p2 @'h2001c3 {
    field TxDqDlyTg3_r1_p2 @0 {
       bits 9;
       access rw;
       reset 9'h10;
    }
  }
  register TxDqsDlyTg0_u1_p2 @'h2001d0 {
    field TxDqsDlyTg0_u1_p2 @0 {
       bits 10;
       access rw;
       reset 10'h100;
    }
  }
  register TxDqsDlyTg1_u1_p2 @'h2001d1 {
    field TxDqsDlyTg1_u1_p2 @0 {
       bits 10;
       access rw;
       reset 10'h100;
    }
  }
  register TxDqsDlyTg2_u1_p2 @'h2001d2 {
    field TxDqsDlyTg2_u1_p2 @0 {
       bits 10;
       access rw;
       reset 10'h100;
    }
  }
  register TxDqsDlyTg3_u1_p2 @'h2001d3 {
    field TxDqsDlyTg3_u1_p2 @0 {
       bits 10;
       access rw;
       reset 10'h100;
    }
  }
  register TxDqDlyTg0_r2_p2 @'h2002c0 {
    field TxDqDlyTg0_r2_p2 @0 {
       bits 9;
       access rw;
       reset 9'h10;
    }
  }
  register TxDqDlyTg1_r2_p2 @'h2002c1 {
    field TxDqDlyTg1_r2_p2 @0 {
       bits 9;
       access rw;
       reset 9'h10;
    }
  }
  register TxDqDlyTg2_r2_p2 @'h2002c2 {
    field TxDqDlyTg2_r2_p2 @0 {
       bits 9;
       access rw;
       reset 9'h10;
    }
  }
  register TxDqDlyTg3_r2_p2 @'h2002c3 {
    field TxDqDlyTg3_r2_p2 @0 {
       bits 9;
       access rw;
       reset 9'h10;
    }
  }
  register TxDqDlyTg0_r3_p2 @'h2003c0 {
    field TxDqDlyTg0_r3_p2 @0 {
       bits 9;
       access rw;
       reset 9'h10;
    }
  }
  register TxDqDlyTg1_r3_p2 @'h2003c1 {
    field TxDqDlyTg1_r3_p2 @0 {
       bits 9;
       access rw;
       reset 9'h10;
    }
  }
  register TxDqDlyTg2_r3_p2 @'h2003c2 {
    field TxDqDlyTg2_r3_p2 @0 {
       bits 9;
       access rw;
       reset 9'h10;
    }
  }
  register TxDqDlyTg3_r3_p2 @'h2003c3 {
    field TxDqDlyTg3_r3_p2 @0 {
       bits 9;
       access rw;
       reset 9'h10;
    }
  }
  register TxDqDlyTg0_r4_p2 @'h2004c0 {
    field TxDqDlyTg0_r4_p2 @0 {
       bits 9;
       access rw;
       reset 9'h10;
    }
  }
  register TxDqDlyTg1_r4_p2 @'h2004c1 {
    field TxDqDlyTg1_r4_p2 @0 {
       bits 9;
       access rw;
       reset 9'h10;
    }
  }
  register TxDqDlyTg2_r4_p2 @'h2004c2 {
    field TxDqDlyTg2_r4_p2 @0 {
       bits 9;
       access rw;
       reset 9'h10;
    }
  }
  register TxDqDlyTg3_r4_p2 @'h2004c3 {
    field TxDqDlyTg3_r4_p2 @0 {
       bits 9;
       access rw;
       reset 9'h10;
    }
  }
  register TxDqDlyTg0_r5_p2 @'h2005c0 {
    field TxDqDlyTg0_r5_p2 @0 {
       bits 9;
       access rw;
       reset 9'h10;
    }
  }
  register TxDqDlyTg1_r5_p2 @'h2005c1 {
    field TxDqDlyTg1_r5_p2 @0 {
       bits 9;
       access rw;
       reset 9'h10;
    }
  }
  register TxDqDlyTg2_r5_p2 @'h2005c2 {
    field TxDqDlyTg2_r5_p2 @0 {
       bits 9;
       access rw;
       reset 9'h10;
    }
  }
  register TxDqDlyTg3_r5_p2 @'h2005c3 {
    field TxDqDlyTg3_r5_p2 @0 {
       bits 9;
       access rw;
       reset 9'h10;
    }
  }
  register TxDqDlyTg0_r6_p2 @'h2006c0 {
    field TxDqDlyTg0_r6_p2 @0 {
       bits 9;
       access rw;
       reset 9'h10;
    }
  }
  register TxDqDlyTg1_r6_p2 @'h2006c1 {
    field TxDqDlyTg1_r6_p2 @0 {
       bits 9;
       access rw;
       reset 9'h10;
    }
  }
  register TxDqDlyTg2_r6_p2 @'h2006c2 {
    field TxDqDlyTg2_r6_p2 @0 {
       bits 9;
       access rw;
       reset 9'h10;
    }
  }
  register TxDqDlyTg3_r6_p2 @'h2006c3 {
    field TxDqDlyTg3_r6_p2 @0 {
       bits 9;
       access rw;
       reset 9'h10;
    }
  }
  register TxDqDlyTg0_r7_p2 @'h2007c0 {
    field TxDqDlyTg0_r7_p2 @0 {
       bits 9;
       access rw;
       reset 9'h10;
    }
  }
  register TxDqDlyTg1_r7_p2 @'h2007c1 {
    field TxDqDlyTg1_r7_p2 @0 {
       bits 9;
       access rw;
       reset 9'h10;
    }
  }
  register TxDqDlyTg2_r7_p2 @'h2007c2 {
    field TxDqDlyTg2_r7_p2 @0 {
       bits 9;
       access rw;
       reset 9'h10;
    }
  }
  register TxDqDlyTg3_r7_p2 @'h2007c3 {
    field TxDqDlyTg3_r7_p2 @0 {
       bits 9;
       access rw;
       reset 9'h10;
    }
  }
  register TxDqDlyTg0_r8_p2 @'h2008c0 {
    field TxDqDlyTg0_r8_p2 @0 {
       bits 9;
       access rw;
       reset 9'h10;
    }
  }
  register TxDqDlyTg1_r8_p2 @'h2008c1 {
    field TxDqDlyTg1_r8_p2 @0 {
       bits 9;
       access rw;
       reset 9'h10;
    }
  }
  register TxDqDlyTg2_r8_p2 @'h2008c2 {
    field TxDqDlyTg2_r8_p2 @0 {
       bits 9;
       access rw;
       reset 9'h10;
    }
  }
  register TxDqDlyTg3_r8_p2 @'h2008c3 {
    field TxDqDlyTg3_r8_p2 @0 {
       bits 9;
       access rw;
       reset 9'h10;
    }
  }
  register UseDqsEnReplica_p3 @'h300003 {
    field UseDqsEnReplica_p3 @0 {
       bits 1;
       access rw;
       reset 1'h0;
    }
  }
  register DFIMRL_p3 @'h300020 {
    field DFIMRL_p3 @0 {
       bits 5;
       access rw;
       reset 5'h6;
    }
  }
  register TxImpedanceCtrl0_b0_p3 @'h300041 {
    field DrvStrenDqP @0 {
       bits 6;
       access rw;
       reset 6'h3f;
    }
    field DrvStrenDqN @6 {
       bits 6;
       access rw;
       reset 6'h3f;
    }
  }
  register DqDqsRcvCntrl_b0_p3 @'h300043 {
    field SelAnalogVref @0 {
       bits 1;
       access rw;
       reset 1'h0;
    }
    field ExtVrefRange @1 {
       bits 1;
       access rw;
       reset 1'h0;
    }
    field DfeCtrl @2 {
       bits 2;
       access rw;
       reset 2'h0;
    }
    field MajorModeDbyte @4 {
       bits 3;
       access rw;
       reset 3'h3;
    }
    field GainCurrAdj @7 {
       bits 5;
       access rw;
       reset 5'hb;
    }
    field Reserved @12 {
       bits 4;
    }
  }
  register TxEqualizationMode_p3 @'h300048 {
    field TxEqMode @0 {
       bits 2;
       access rw;
       reset 2'h0;
    }
  }
  register TxImpedanceCtrl1_b0_p3 @'h300049 {
    field DrvStrenFSDqP @0 {
       bits 6;
       access rw;
       reset 6'h3f;
    }
    field DrvStrenFSDqN @6 {
       bits 6;
       access rw;
       reset 6'h3f;
    }
  }
  register TxImpedanceCtrl2_b0_p3 @'h30004b {
    field DrvStrenEQHiDqP @0 {
       bits 6;
       access rw;
       reset 6'h0;
    }
    field DrvStrenEQLoDqN @6 {
       bits 6;
       access rw;
       reset 6'h0;
    }
  }
  register DqDqsRcvCntrl2_p3 @'h30004c {
    field EnRxAgressivePDR @0 {
       bits 1;
       access rw;
       reset 1'h0;
    }
  }
  register TxOdtDrvStren_b0_p3 @'h30004d {
    field ODTStrenP @0 {
       bits 6;
       access rw;
       reset 6'h0;
    }
    field ODTStrenN @6 {
       bits 6;
       access rw;
       reset 6'h0;
    }
  }
  register TxSlewRate_b0_p3 @'h30005f {
    field TxPreP @0 {
       bits 4;
       access rw;
       reset 4'hf;
    }
    field TxPreN @4 {
       bits 4;
       access rw;
       reset 4'hf;
    }
    field TxPreDrvMode @8 {
       bits 3;
       access rw;
       reset 3'h7;
    }
  }
  register RxEnDlyTg0_u0_p3 @'h300080 {
    field RxEnDlyTg0_u0_p3 @0 {
       bits 11;
       access rw;
       reset 11'h100;
    }
  }
  register RxEnDlyTg1_u0_p3 @'h300081 {
    field RxEnDlyTg1_u0_p3 @0 {
       bits 11;
       access rw;
       reset 11'h100;
    }
  }
  register RxEnDlyTg2_u0_p3 @'h300082 {
    field RxEnDlyTg2_u0_p3 @0 {
       bits 11;
       access rw;
       reset 11'h100;
    }
  }
  register RxEnDlyTg3_u0_p3 @'h300083 {
    field RxEnDlyTg3_u0_p3 @0 {
       bits 11;
       access rw;
       reset 11'h100;
    }
  }
  register RxClkDlyTg0_u0_p3 @'h30008c {
    field RxClkDlyTg0_u0_p3 @0 {
       bits 6;
       access rw;
       reset 6'h10;
    }
  }
  register RxClkDlyTg1_u0_p3 @'h30008d {
    field RxClkDlyTg1_u0_p3 @0 {
       bits 6;
       access rw;
       reset 6'h10;
    }
  }
  register RxClkDlyTg2_u0_p3 @'h30008e {
    field RxClkDlyTg2_u0_p3 @0 {
       bits 6;
       access rw;
       reset 6'h10;
    }
  }
  register RxClkDlyTg3_u0_p3 @'h30008f {
    field RxClkDlyTg3_u0_p3 @0 {
       bits 6;
       access rw;
       reset 6'h10;
    }
  }
  register RxClkcDlyTg0_u0_p3 @'h300090 {
    field RxClkcDlyTg0_u0_p3 @0 {
       bits 6;
       access rw;
       reset 6'h10;
    }
  }
  register RxClkcDlyTg1_u0_p3 @'h300091 {
    field RxClkcDlyTg1_u0_p3 @0 {
       bits 6;
       access rw;
       reset 6'h10;
    }
  }
  register RxClkcDlyTg2_u0_p3 @'h300092 {
    field RxClkcDlyTg2_u0_p3 @0 {
       bits 6;
       access rw;
       reset 6'h10;
    }
  }
  register RxClkcDlyTg3_u0_p3 @'h300093 {
    field RxClkcDlyTg3_u0_p3 @0 {
       bits 6;
       access rw;
       reset 6'h10;
    }
  }
  register PptDqsCntInvTrnTg0_p3 @'h3000ae {
    field PptDqsCntInvTrnTg0_p3 @0 {
       bits 16;
       access rw;
       reset 16'h0;
    }
  }
  register PptDqsCntInvTrnTg1_p3 @'h3000af {
    field PptDqsCntInvTrnTg1_p3 @0 {
       bits 16;
       access rw;
       reset 16'h0;
    }
  }
  register TxDqDlyTg0_r0_p3 @'h3000c0 {
    field TxDqDlyTg0_r0_p3 @0 {
       bits 9;
       access rw;
       reset 9'h10;
    }
  }
  register TxDqDlyTg1_r0_p3 @'h3000c1 {
    field TxDqDlyTg1_r0_p3 @0 {
       bits 9;
       access rw;
       reset 9'h10;
    }
  }
  register TxDqDlyTg2_r0_p3 @'h3000c2 {
    field TxDqDlyTg2_r0_p3 @0 {
       bits 9;
       access rw;
       reset 9'h10;
    }
  }
  register TxDqDlyTg3_r0_p3 @'h3000c3 {
    field TxDqDlyTg3_r0_p3 @0 {
       bits 9;
       access rw;
       reset 9'h10;
    }
  }
  register TxDqsDlyTg0_u0_p3 @'h3000d0 {
    field TxDqsDlyTg0_u0_p3 @0 {
       bits 10;
       access rw;
       reset 10'h100;
    }
  }
  register TxDqsDlyTg1_u0_p3 @'h3000d1 {
    field TxDqsDlyTg1_u0_p3 @0 {
       bits 10;
       access rw;
       reset 10'h100;
    }
  }
  register TxDqsDlyTg2_u0_p3 @'h3000d2 {
    field TxDqsDlyTg2_u0_p3 @0 {
       bits 10;
       access rw;
       reset 10'h100;
    }
  }
  register TxDqsDlyTg3_u0_p3 @'h3000d3 {
    field TxDqsDlyTg3_u0_p3 @0 {
       bits 10;
       access rw;
       reset 10'h100;
    }
  }
  register TxImpedanceCtrl0_b1_p3 @'h300141 {
    field DrvStrenDqP @0 {
       bits 6;
       access rw;
       reset 6'h3f;
    }
    field DrvStrenDqN @6 {
       bits 6;
       access rw;
       reset 6'h3f;
    }
  }
  register DqDqsRcvCntrl_b1_p3 @'h300143 {
    field SelAnalogVref @0 {
       bits 1;
       access rw;
       reset 1'h0;
    }
    field ExtVrefRange @1 {
       bits 1;
       access rw;
       reset 1'h0;
    }
    field DfeCtrl @2 {
       bits 2;
       access rw;
       reset 2'h0;
    }
    field MajorModeDbyte @4 {
       bits 3;
       access rw;
       reset 3'h3;
    }
    field GainCurrAdj @7 {
       bits 5;
       access rw;
       reset 5'hb;
    }
    field Reserved @12 {
       bits 4;
    }
  }
  register TxImpedanceCtrl1_b1_p3 @'h300149 {
    field DrvStrenFSDqP @0 {
       bits 6;
       access rw;
       reset 6'h3f;
    }
    field DrvStrenFSDqN @6 {
       bits 6;
       access rw;
       reset 6'h3f;
    }
  }
  register TxImpedanceCtrl2_b1_p3 @'h30014b {
    field DrvStrenEQHiDqP @0 {
       bits 6;
       access rw;
       reset 6'h0;
    }
    field DrvStrenEQLoDqN @6 {
       bits 6;
       access rw;
       reset 6'h0;
    }
  }
  register TxOdtDrvStren_b1_p3 @'h30014d {
    field ODTStrenP @0 {
       bits 6;
       access rw;
       reset 6'h0;
    }
    field ODTStrenN @6 {
       bits 6;
       access rw;
       reset 6'h0;
    }
  }
  register TxSlewRate_b1_p3 @'h30015f {
    field TxPreP @0 {
       bits 4;
       access rw;
       reset 4'hf;
    }
    field TxPreN @4 {
       bits 4;
       access rw;
       reset 4'hf;
    }
    field TxPreDrvMode @8 {
       bits 3;
       access rw;
       reset 3'h7;
    }
  }
  register RxEnDlyTg0_u1_p3 @'h300180 {
    field RxEnDlyTg0_u1_p3 @0 {
       bits 11;
       access rw;
       reset 11'h100;
    }
  }
  register RxEnDlyTg1_u1_p3 @'h300181 {
    field RxEnDlyTg1_u1_p3 @0 {
       bits 11;
       access rw;
       reset 11'h100;
    }
  }
  register RxEnDlyTg2_u1_p3 @'h300182 {
    field RxEnDlyTg2_u1_p3 @0 {
       bits 11;
       access rw;
       reset 11'h100;
    }
  }
  register RxEnDlyTg3_u1_p3 @'h300183 {
    field RxEnDlyTg3_u1_p3 @0 {
       bits 11;
       access rw;
       reset 11'h100;
    }
  }
  register RxClkDlyTg0_u1_p3 @'h30018c {
    field RxClkDlyTg0_u1_p3 @0 {
       bits 6;
       access rw;
       reset 6'h10;
    }
  }
  register RxClkDlyTg1_u1_p3 @'h30018d {
    field RxClkDlyTg1_u1_p3 @0 {
       bits 6;
       access rw;
       reset 6'h10;
    }
  }
  register RxClkDlyTg2_u1_p3 @'h30018e {
    field RxClkDlyTg2_u1_p3 @0 {
       bits 6;
       access rw;
       reset 6'h10;
    }
  }
  register RxClkDlyTg3_u1_p3 @'h30018f {
    field RxClkDlyTg3_u1_p3 @0 {
       bits 6;
       access rw;
       reset 6'h10;
    }
  }
  register RxClkcDlyTg0_u1_p3 @'h300190 {
    field RxClkcDlyTg0_u1_p3 @0 {
       bits 6;
       access rw;
       reset 6'h10;
    }
  }
  register RxClkcDlyTg1_u1_p3 @'h300191 {
    field RxClkcDlyTg1_u1_p3 @0 {
       bits 6;
       access rw;
       reset 6'h10;
    }
  }
  register RxClkcDlyTg2_u1_p3 @'h300192 {
    field RxClkcDlyTg2_u1_p3 @0 {
       bits 6;
       access rw;
       reset 6'h10;
    }
  }
  register RxClkcDlyTg3_u1_p3 @'h300193 {
    field RxClkcDlyTg3_u1_p3 @0 {
       bits 6;
       access rw;
       reset 6'h10;
    }
  }
  register TxDqDlyTg0_r1_p3 @'h3001c0 {
    field TxDqDlyTg0_r1_p3 @0 {
       bits 9;
       access rw;
       reset 9'h10;
    }
  }
  register TxDqDlyTg1_r1_p3 @'h3001c1 {
    field TxDqDlyTg1_r1_p3 @0 {
       bits 9;
       access rw;
       reset 9'h10;
    }
  }
  register TxDqDlyTg2_r1_p3 @'h3001c2 {
    field TxDqDlyTg2_r1_p3 @0 {
       bits 9;
       access rw;
       reset 9'h10;
    }
  }
  register TxDqDlyTg3_r1_p3 @'h3001c3 {
    field TxDqDlyTg3_r1_p3 @0 {
       bits 9;
       access rw;
       reset 9'h10;
    }
  }
  register TxDqsDlyTg0_u1_p3 @'h3001d0 {
    field TxDqsDlyTg0_u1_p3 @0 {
       bits 10;
       access rw;
       reset 10'h100;
    }
  }
  register TxDqsDlyTg1_u1_p3 @'h3001d1 {
    field TxDqsDlyTg1_u1_p3 @0 {
       bits 10;
       access rw;
       reset 10'h100;
    }
  }
  register TxDqsDlyTg2_u1_p3 @'h3001d2 {
    field TxDqsDlyTg2_u1_p3 @0 {
       bits 10;
       access rw;
       reset 10'h100;
    }
  }
  register TxDqsDlyTg3_u1_p3 @'h3001d3 {
    field TxDqsDlyTg3_u1_p3 @0 {
       bits 10;
       access rw;
       reset 10'h100;
    }
  }
  register TxDqDlyTg0_r2_p3 @'h3002c0 {
    field TxDqDlyTg0_r2_p3 @0 {
       bits 9;
       access rw;
       reset 9'h10;
    }
  }
  register TxDqDlyTg1_r2_p3 @'h3002c1 {
    field TxDqDlyTg1_r2_p3 @0 {
       bits 9;
       access rw;
       reset 9'h10;
    }
  }
  register TxDqDlyTg2_r2_p3 @'h3002c2 {
    field TxDqDlyTg2_r2_p3 @0 {
       bits 9;
       access rw;
       reset 9'h10;
    }
  }
  register TxDqDlyTg3_r2_p3 @'h3002c3 {
    field TxDqDlyTg3_r2_p3 @0 {
       bits 9;
       access rw;
       reset 9'h10;
    }
  }
  register TxDqDlyTg0_r3_p3 @'h3003c0 {
    field TxDqDlyTg0_r3_p3 @0 {
       bits 9;
       access rw;
       reset 9'h10;
    }
  }
  register TxDqDlyTg1_r3_p3 @'h3003c1 {
    field TxDqDlyTg1_r3_p3 @0 {
       bits 9;
       access rw;
       reset 9'h10;
    }
  }
  register TxDqDlyTg2_r3_p3 @'h3003c2 {
    field TxDqDlyTg2_r3_p3 @0 {
       bits 9;
       access rw;
       reset 9'h10;
    }
  }
  register TxDqDlyTg3_r3_p3 @'h3003c3 {
    field TxDqDlyTg3_r3_p3 @0 {
       bits 9;
       access rw;
       reset 9'h10;
    }
  }
  register TxDqDlyTg0_r4_p3 @'h3004c0 {
    field TxDqDlyTg0_r4_p3 @0 {
       bits 9;
       access rw;
       reset 9'h10;
    }
  }
  register TxDqDlyTg1_r4_p3 @'h3004c1 {
    field TxDqDlyTg1_r4_p3 @0 {
       bits 9;
       access rw;
       reset 9'h10;
    }
  }
  register TxDqDlyTg2_r4_p3 @'h3004c2 {
    field TxDqDlyTg2_r4_p3 @0 {
       bits 9;
       access rw;
       reset 9'h10;
    }
  }
  register TxDqDlyTg3_r4_p3 @'h3004c3 {
    field TxDqDlyTg3_r4_p3 @0 {
       bits 9;
       access rw;
       reset 9'h10;
    }
  }
  register TxDqDlyTg0_r5_p3 @'h3005c0 {
    field TxDqDlyTg0_r5_p3 @0 {
       bits 9;
       access rw;
       reset 9'h10;
    }
  }
  register TxDqDlyTg1_r5_p3 @'h3005c1 {
    field TxDqDlyTg1_r5_p3 @0 {
       bits 9;
       access rw;
       reset 9'h10;
    }
  }
  register TxDqDlyTg2_r5_p3 @'h3005c2 {
    field TxDqDlyTg2_r5_p3 @0 {
       bits 9;
       access rw;
       reset 9'h10;
    }
  }
  register TxDqDlyTg3_r5_p3 @'h3005c3 {
    field TxDqDlyTg3_r5_p3 @0 {
       bits 9;
       access rw;
       reset 9'h10;
    }
  }
  register TxDqDlyTg0_r6_p3 @'h3006c0 {
    field TxDqDlyTg0_r6_p3 @0 {
       bits 9;
       access rw;
       reset 9'h10;
    }
  }
  register TxDqDlyTg1_r6_p3 @'h3006c1 {
    field TxDqDlyTg1_r6_p3 @0 {
       bits 9;
       access rw;
       reset 9'h10;
    }
  }
  register TxDqDlyTg2_r6_p3 @'h3006c2 {
    field TxDqDlyTg2_r6_p3 @0 {
       bits 9;
       access rw;
       reset 9'h10;
    }
  }
  register TxDqDlyTg3_r6_p3 @'h3006c3 {
    field TxDqDlyTg3_r6_p3 @0 {
       bits 9;
       access rw;
       reset 9'h10;
    }
  }
  register TxDqDlyTg0_r7_p3 @'h3007c0 {
    field TxDqDlyTg0_r7_p3 @0 {
       bits 9;
       access rw;
       reset 9'h10;
    }
  }
  register TxDqDlyTg1_r7_p3 @'h3007c1 {
    field TxDqDlyTg1_r7_p3 @0 {
       bits 9;
       access rw;
       reset 9'h10;
    }
  }
  register TxDqDlyTg2_r7_p3 @'h3007c2 {
    field TxDqDlyTg2_r7_p3 @0 {
       bits 9;
       access rw;
       reset 9'h10;
    }
  }
  register TxDqDlyTg3_r7_p3 @'h3007c3 {
    field TxDqDlyTg3_r7_p3 @0 {
       bits 9;
       access rw;
       reset 9'h10;
    }
  }
  register TxDqDlyTg0_r8_p3 @'h3008c0 {
    field TxDqDlyTg0_r8_p3 @0 {
       bits 9;
       access rw;
       reset 9'h10;
    }
  }
  register TxDqDlyTg1_r8_p3 @'h3008c1 {
    field TxDqDlyTg1_r8_p3 @0 {
       bits 9;
       access rw;
       reset 9'h10;
    }
  }
  register TxDqDlyTg2_r8_p3 @'h3008c2 {
    field TxDqDlyTg2_r8_p3 @0 {
       bits 9;
       access rw;
       reset 9'h10;
    }
  }
  register TxDqDlyTg3_r8_p3 @'h3008c3 {
    field TxDqDlyTg3_r8_p3 @0 {
       bits 9;
       access rw;
       reset 9'h10;
    }
  }
}
block dwc_ddrphy_top_DWC_DDRPHYA_DBYTE5 {
  endian little;
  bytes 2;
  register DbyteMiscMode @'h0 {
    field Reserved @0 {
       bits 2;
    }
    field DByteDisable @2 {
       bits 1;
       access rw;
       reset 1'h0;
    }
  }
  register TsmByte0 @'h1 {
    field RFU_TsmByte0 @0 {
       bits 16;
       access rw;
       reset 16'h0;
    }
  }
  register TrainingParam @'h2 {
    field RFU_TrainingParam @0 {
       bits 16;
       access rw;
       reset 16'h0;
    }
  }
  register UseDqsEnReplica_p0 @'h3 {
    field UseDqsEnReplica_p0 @0 {
       bits 1;
       access rw;
       reset 1'h0;
    }
  }
  register RxTrainPatternEnable @'h10 {
    field RxTrainPatternEnable @0 {
       bits 1;
       access rw;
       reset 1'h0;
    }
  }
  register TsmByte1 @'h11 {
    field RFU_TsmByte1 @0 {
       bits 16;
       access rw;
       reset 16'h0;
    }
  }
  register TsmByte2 @'h12 {
    field RFU_TsmByte2 @0 {
       bits 16;
       access rw;
       reset 16'h0;
    }
  }
  register TsmByte3 @'h13 {
    field RFU_TsmByte3 @0 {
       bits 9;
       access rw;
       reset 9'h0;
    }
  }
  register TsmByte4 @'h14 {
    field RFU_TsmByte4 @0 {
       bits 4;
       access rw;
       reset 4'h0;
    }
  }
  register TestModeConfig @'h17 {
    field RFU_TestModeConfig @0 {
       bits 10;
       access rw;
       reset 10'h0;
    }
  }
  register TsmByte5 @'h18 {
    field RFU_TsmByte5 @0 {
       bits 16;
       access rw;
       reset 16'h0;
    }
  }
  register MtestMuxSel @'h1a {
    field MtestMuxSel @0 {
       bits 6;
       access rw;
       reset 6'h0;
    }
  }
  register DtsmTrainModeCtrl @'h1f {
    field RFU_DtsmTrainModeCtrl @0 {
       bits 4;
       access rw;
       reset 4'h0;
    }
  }
  register DFIMRL_p0 @'h20 {
    field DFIMRL_p0 @0 {
       bits 5;
       access rw;
       reset 5'h6;
    }
  }
  register AsyncDbyteMode @'h24 {
    field AsyncDbyteMode @0 {
       bits 9;
       access rw;
       reset 9'h0;
    }
  }
  register AsyncDbyteTxEn @'h26 {
    field AsyncDbyteTxEn @0 {
       bits 12;
       access rw;
       reset 12'h0;
    }
  }
  register AsyncDbyteTxData @'h28 {
    field AsyncDbyteTxData @0 {
       bits 12;
       access rw;
       reset 12'h0;
    }
  }
  register AsyncDbyteRxData @'h2a {
    field AsyncDbyteRxData @0 {
       bits 12;
       access ro;
       reset 12'h0;
    }
  }
  register VrefDAC1_r0 @'h30 {
    field VrefDAC1_r0 @0 {
       bits 7;
       access rw;
       reset 7'h0;
    }
  }
  register TrainingCntr_r0 @'h32 {
    field RFU_TrainingCntr_r0 @0 {
       bits 16;
       access rw;
       reset 16'h0;
    }
  }
  register VrefDAC0_r0 @'h40 {
    field VrefDAC0_r0 @0 {
       bits 7;
       access rw;
       reset 7'h0;
    }
  }
  register TxImpedanceCtrl0_b0_p0 @'h41 {
    field DrvStrenDqP @0 {
       bits 6;
       access rw;
       reset 6'h3f;
    }
    field DrvStrenDqN @6 {
       bits 6;
       access rw;
       reset 6'h3f;
    }
  }
  register DqDqsRcvCntrl_b0_p0 @'h43 {
    field SelAnalogVref @0 {
       bits 1;
       access rw;
       reset 1'h0;
    }
    field ExtVrefRange @1 {
       bits 1;
       access rw;
       reset 1'h0;
    }
    field DfeCtrl @2 {
       bits 2;
       access rw;
       reset 2'h0;
    }
    field MajorModeDbyte @4 {
       bits 3;
       access rw;
       reset 3'h3;
    }
    field GainCurrAdj @7 {
       bits 5;
       access rw;
       reset 5'hb;
    }
    field Reserved @12 {
       bits 4;
    }
  }
  register TxEqualizationMode_p0 @'h48 {
    field TxEqMode @0 {
       bits 2;
       access rw;
       reset 2'h0;
    }
  }
  register TxImpedanceCtrl1_b0_p0 @'h49 {
    field DrvStrenFSDqP @0 {
       bits 6;
       access rw;
       reset 6'h3f;
    }
    field DrvStrenFSDqN @6 {
       bits 6;
       access rw;
       reset 6'h3f;
    }
  }
  register DqDqsRcvCntrl1 @'h4a {
    field PowerDownRcvr @0 {
       bits 9;
       access rw;
       reset 9'h0;
    }
    field PowerDownRcvrDqs @9 {
       bits 1;
       access rw;
       reset 1'h0;
    }
    field RxPadStandbyEn @10 {
       bits 1;
       access rw;
       reset 1'h1;
    }
    field EnLPReqPDR @11 {
       bits 1;
       access rw;
       reset 1'h0;
    }
  }
  register TxImpedanceCtrl2_b0_p0 @'h4b {
    field DrvStrenEQHiDqP @0 {
       bits 6;
       access rw;
       reset 6'h0;
    }
    field DrvStrenEQLoDqN @6 {
       bits 6;
       access rw;
       reset 6'h0;
    }
  }
  register DqDqsRcvCntrl2_p0 @'h4c {
    field EnRxAgressivePDR @0 {
       bits 1;
       access rw;
       reset 1'h0;
    }
  }
  register TxOdtDrvStren_b0_p0 @'h4d {
    field ODTStrenP @0 {
       bits 6;
       access rw;
       reset 6'h0;
    }
    field ODTStrenN @6 {
       bits 6;
       access rw;
       reset 6'h0;
    }
  }
  register RxFifoCheckStatus @'h56 {
    field RxFifoLocErr @0 {
       bits 1;
       access ro;
       reset 1'h0;
    }
    field RxFifoLocUErr @1 {
       bits 1;
       access ro;
       reset 1'h0;
    }
  }
  register RxFifoCheckErrValues @'h57 {
    field RxFifoRdLocErrValue @0 {
       bits 4;
       access ro;
       reset 4'h0;
    }
    field RxFifoWrLocErrValue @4 {
       bits 4;
       access ro;
       reset 4'h0;
    }
    field RxFifoRdLocUErrValue @8 {
       bits 4;
       access ro;
       reset 4'h0;
    }
    field RxFifoWrLocUErrValue @12 {
       bits 4;
       access ro;
       reset 4'h0;
    }
  }
  register RxFifoInfo @'h58 {
    field RxFifoRdLoc @0 {
       bits 4;
       access ro;
       reset 4'h0;
    }
    field RxFifoWrLoc @4 {
       bits 4;
       access ro;
       reset 4'h0;
    }
    field RxFifoRdLocU @8 {
       bits 4;
       access ro;
       reset 4'h0;
    }
    field RxFifoWrLocU @12 {
       bits 4;
       access ro;
       reset 4'h0;
    }
  }
  register RxFifoVisibility @'h59 {
    field RxFifoRdPtr @0 {
       bits 3;
       access rw;
       reset 3'h0;
    }
    field RxFifoRdPtrOvr @3 {
       bits 1;
       access rw;
       reset 1'h0;
    }
    field RxFifoRdEn @4 {
       bits 1;
       access rw;
       reset 1'h0;
    }
  }
  register RxFifoContentsDQ3210 @'h5a {
    field RxFifoContentsDQ3210 @0 {
       bits 16;
       access ro;
       reset 16'h0;
    }
  }
  register RxFifoContentsDQ7654 @'h5b {
    field RxFifoContentsDQ7654 @0 {
       bits 16;
       access ro;
       reset 16'h0;
    }
  }
  register RxFifoContentsDBI @'h5c {
    field RxFifoContentsDBI @0 {
       bits 4;
       access ro;
       reset 4'h0;
    }
  }
  register TxSlewRate_b0_p0 @'h5f {
    field TxPreP @0 {
       bits 4;
       access rw;
       reset 4'hf;
    }
    field TxPreN @4 {
       bits 4;
       access rw;
       reset 4'hf;
    }
    field TxPreDrvMode @8 {
       bits 3;
       access rw;
       reset 3'h7;
    }
  }
  register TrainingIncDecDtsmEn_r0 @'h62 {
    field TrainingIncDecDtsmEn_r0 @0 {
       bits 9;
       access rw;
       reset 9'h0;
    }
  }
  register RxPBDlyTg0_r0 @'h68 {
    field RxPBDlyTg0_r0 @0 {
       bits 7;
       access rw;
       reset 7'h0;
    }
  }
  register RxPBDlyTg1_r0 @'h69 {
    field RxPBDlyTg1_r0 @0 {
       bits 7;
       access rw;
       reset 7'h0;
    }
  }
  register RxPBDlyTg2_r0 @'h6a {
    field RxPBDlyTg2_r0 @0 {
       bits 7;
       access rw;
       reset 7'h0;
    }
  }
  register RxPBDlyTg3_r0 @'h6b {
    field RxPBDlyTg3_r0 @0 {
       bits 7;
       access rw;
       reset 7'h0;
    }
  }
  register RxEnDlyTg0_u0_p0 @'h80 {
    field RxEnDlyTg0_u0_p0 @0 {
       bits 11;
       access rw;
       reset 11'h100;
    }
  }
  register RxEnDlyTg1_u0_p0 @'h81 {
    field RxEnDlyTg1_u0_p0 @0 {
       bits 11;
       access rw;
       reset 11'h100;
    }
  }
  register RxEnDlyTg2_u0_p0 @'h82 {
    field RxEnDlyTg2_u0_p0 @0 {
       bits 11;
       access rw;
       reset 11'h100;
    }
  }
  register RxEnDlyTg3_u0_p0 @'h83 {
    field RxEnDlyTg3_u0_p0 @0 {
       bits 11;
       access rw;
       reset 11'h100;
    }
  }
  register RxClkDlyTg0_u0_p0 @'h8c {
    field RxClkDlyTg0_u0_p0 @0 {
       bits 6;
       access rw;
       reset 6'h10;
    }
  }
  register RxClkDlyTg1_u0_p0 @'h8d {
    field RxClkDlyTg1_u0_p0 @0 {
       bits 6;
       access rw;
       reset 6'h10;
    }
  }
  register RxClkDlyTg2_u0_p0 @'h8e {
    field RxClkDlyTg2_u0_p0 @0 {
       bits 6;
       access rw;
       reset 6'h10;
    }
  }
  register RxClkDlyTg3_u0_p0 @'h8f {
    field RxClkDlyTg3_u0_p0 @0 {
       bits 6;
       access rw;
       reset 6'h10;
    }
  }
  register RxClkcDlyTg0_u0_p0 @'h90 {
    field RxClkcDlyTg0_u0_p0 @0 {
       bits 6;
       access rw;
       reset 6'h10;
    }
  }
  register RxClkcDlyTg1_u0_p0 @'h91 {
    field RxClkcDlyTg1_u0_p0 @0 {
       bits 6;
       access rw;
       reset 6'h10;
    }
  }
  register RxClkcDlyTg2_u0_p0 @'h92 {
    field RxClkcDlyTg2_u0_p0 @0 {
       bits 6;
       access rw;
       reset 6'h10;
    }
  }
  register RxClkcDlyTg3_u0_p0 @'h93 {
    field RxClkcDlyTg3_u0_p0 @0 {
       bits 6;
       access rw;
       reset 6'h10;
    }
  }
  register Dq0LnSel @'ha0 {
    field Dq0LnSel @0 {
       bits 3;
       access rw;
       reset 3'h0;
    }
  }
  register Dq1LnSel @'ha1 {
    field Dq1LnSel @0 {
       bits 3;
       access rw;
       reset 3'h1;
    }
  }
  register Dq2LnSel @'ha2 {
    field Dq2LnSel @0 {
       bits 3;
       access rw;
       reset 3'h2;
    }
  }
  register Dq3LnSel @'ha3 {
    field Dq3LnSel @0 {
       bits 3;
       access rw;
       reset 3'h3;
    }
  }
  register Dq4LnSel @'ha4 {
    field Dq4LnSel @0 {
       bits 3;
       access rw;
       reset 3'h4;
    }
  }
  register Dq5LnSel @'ha5 {
    field Dq5LnSel @0 {
       bits 3;
       access rw;
       reset 3'h5;
    }
  }
  register Dq6LnSel @'ha6 {
    field Dq6LnSel @0 {
       bits 3;
       access rw;
       reset 3'h6;
    }
  }
  register Dq7LnSel @'ha7 {
    field Dq7LnSel @0 {
       bits 3;
       access rw;
       reset 3'h7;
    }
  }
  register PptCtlStatic @'haa {
    field RFU_PptCtlStatic @0 {
       bits 12;
       access rw;
       reset 12'h0;
    }
  }
  register PptCtlDyn @'hab {
    field RFU_PptCtlDyn @0 {
       bits 2;
       access rw;
       reset 2'h0;
    }
  }
  register PptInfo @'hac {
    field PptInfo @0 {
       bits 16;
       access ro;
       reset 16'h0;
    }
  }
  register PptRxEnEvnt @'had {
    field RFU_PptRxEnEvnt @0 {
       bits 2;
       access rw;
       reset 2'h0;
    }
  }
  register PptDqsCntInvTrnTg0_p0 @'hae {
    field PptDqsCntInvTrnTg0_p0 @0 {
       bits 16;
       access rw;
       reset 16'h0;
    }
  }
  register PptDqsCntInvTrnTg1_p0 @'haf {
    field PptDqsCntInvTrnTg1_p0 @0 {
       bits 16;
       access rw;
       reset 16'h0;
    }
  }
  register DtsmBlankingCtrl @'hb1 {
    field RFU_DtsmBlankingCtrl @0 {
       bits 10;
       access rw;
       reset 10'h0;
    }
  }
  register Tsm0_i0 @'hb2 {
    field RFU_Tsm0_i0 @0 {
       bits 14;
       access rw;
       reset 14'h0;
    }
  }
  register Tsm1_i0 @'hb3 {
    field RFU_Tsm1_i0 @0 {
       bits 16;
       access ro;
       reset 16'h0;
    }
  }
  register Tsm2_i0 @'hb4 {
    field RFU_Tsm2_i0 @0 {
       bits 1;
       access rw;
       reset 1'h0;
    }
  }
  register Tsm3 @'hb5 {
    field RFU_Tsm3 @0 {
       bits 10;
       access rw;
       reset 10'h0;
    }
  }
  register TxChkDataSelects @'hb6 {
    field RFU_TxChkDataSelects @0 {
       bits 2;
       access rw;
       reset 2'h0;
    }
  }
  register DtsmUpThldXingInd @'hb7 {
    field DtsmUpThldXingInd @0 {
       bits 9;
       access ro;
       reset 9'h0;
    }
  }
  register DtsmLoThldXingInd @'hb8 {
    field DtsmLoThldXingInd @0 {
       bits 9;
       access ro;
       reset 9'h0;
    }
  }
  register DbyteAllDtsmCtrl0 @'hb9 {
    field RFU_DbyteAllDtsmCtrl0 @0 {
       bits 9;
       access rw;
       reset 9'h0;
    }
  }
  register DbyteAllDtsmCtrl1 @'hba {
    field RFU_DbyteAllDtsmCtrl1 @0 {
       bits 9;
       access rw;
       reset 9'h0;
    }
  }
  register DbyteAllDtsmCtrl2 @'hbb {
    field RFU_DbyteAllDtsmCtrl2 @0 {
       bits 9;
       access rw;
       reset 9'h0;
    }
  }
  register TxDqDlyTg0_r0_p0 @'hc0 {
    field TxDqDlyTg0_r0_p0 @0 {
       bits 9;
       access rw;
       reset 9'h10;
    }
  }
  register TxDqDlyTg1_r0_p0 @'hc1 {
    field TxDqDlyTg1_r0_p0 @0 {
       bits 9;
       access rw;
       reset 9'h10;
    }
  }
  register TxDqDlyTg2_r0_p0 @'hc2 {
    field TxDqDlyTg2_r0_p0 @0 {
       bits 9;
       access rw;
       reset 9'h10;
    }
  }
  register TxDqDlyTg3_r0_p0 @'hc3 {
    field TxDqDlyTg3_r0_p0 @0 {
       bits 9;
       access rw;
       reset 9'h10;
    }
  }
  register TxDqsDlyTg0_u0_p0 @'hd0 {
    field TxDqsDlyTg0_u0_p0 @0 {
       bits 10;
       access rw;
       reset 10'h100;
    }
  }
  register TxDqsDlyTg1_u0_p0 @'hd1 {
    field TxDqsDlyTg1_u0_p0 @0 {
       bits 10;
       access rw;
       reset 10'h100;
    }
  }
  register TxDqsDlyTg2_u0_p0 @'hd2 {
    field TxDqsDlyTg2_u0_p0 @0 {
       bits 10;
       access rw;
       reset 10'h100;
    }
  }
  register TxDqsDlyTg3_u0_p0 @'hd3 {
    field TxDqsDlyTg3_u0_p0 @0 {
       bits 10;
       access rw;
       reset 10'h100;
    }
  }
  register DxLcdlStatus @'he4 {
    field DxLcdlFineSnapVal @0 {
       bits 10;
       access ro;
       reset 10'h0;
    }
    field DxLcdlPhdSnapVal @10 {
       bits 1;
       access ro;
       reset 1'h0;
    }
    field DxLcdlStickyLock @11 {
       bits 1;
       access ro;
       reset 1'h0;
    }
    field DxLcdlStickyUnlock @12 {
       bits 1;
       access ro;
       reset 1'h0;
    }
    field DxLcdlLiveLock @13 {
       bits 1;
       access ro;
       reset 1'h0;
    }
  }
  register VrefDAC1_r1 @'h130 {
    field VrefDAC1_r1 @0 {
       bits 7;
       access rw;
       reset 7'h0;
    }
  }
  register TrainingCntr_r1 @'h132 {
    field RFU_TrainingCntr_r1 @0 {
       bits 16;
       access rw;
       reset 16'h0;
    }
  }
  register VrefDAC0_r1 @'h140 {
    field VrefDAC0_r1 @0 {
       bits 7;
       access rw;
       reset 7'h0;
    }
  }
  register TxImpedanceCtrl0_b1_p0 @'h141 {
    field DrvStrenDqP @0 {
       bits 6;
       access rw;
       reset 6'h3f;
    }
    field DrvStrenDqN @6 {
       bits 6;
       access rw;
       reset 6'h3f;
    }
  }
  register DqDqsRcvCntrl_b1_p0 @'h143 {
    field SelAnalogVref @0 {
       bits 1;
       access rw;
       reset 1'h0;
    }
    field ExtVrefRange @1 {
       bits 1;
       access rw;
       reset 1'h0;
    }
    field DfeCtrl @2 {
       bits 2;
       access rw;
       reset 2'h0;
    }
    field MajorModeDbyte @4 {
       bits 3;
       access rw;
       reset 3'h3;
    }
    field GainCurrAdj @7 {
       bits 5;
       access rw;
       reset 5'hb;
    }
    field Reserved @12 {
       bits 4;
    }
  }
  register TxImpedanceCtrl1_b1_p0 @'h149 {
    field DrvStrenFSDqP @0 {
       bits 6;
       access rw;
       reset 6'h3f;
    }
    field DrvStrenFSDqN @6 {
       bits 6;
       access rw;
       reset 6'h3f;
    }
  }
  register TxImpedanceCtrl2_b1_p0 @'h14b {
    field DrvStrenEQHiDqP @0 {
       bits 6;
       access rw;
       reset 6'h0;
    }
    field DrvStrenEQLoDqN @6 {
       bits 6;
       access rw;
       reset 6'h0;
    }
  }
  register TxOdtDrvStren_b1_p0 @'h14d {
    field ODTStrenP @0 {
       bits 6;
       access rw;
       reset 6'h0;
    }
    field ODTStrenN @6 {
       bits 6;
       access rw;
       reset 6'h0;
    }
  }
  register TxSlewRate_b1_p0 @'h15f {
    field TxPreP @0 {
       bits 4;
       access rw;
       reset 4'hf;
    }
    field TxPreN @4 {
       bits 4;
       access rw;
       reset 4'hf;
    }
    field TxPreDrvMode @8 {
       bits 3;
       access rw;
       reset 3'h7;
    }
  }
  register TrainingIncDecDtsmEn_r1 @'h162 {
    field TrainingIncDecDtsmEn_r1 @0 {
       bits 9;
       access rw;
       reset 9'h0;
    }
  }
  register RxPBDlyTg0_r1 @'h168 {
    field RxPBDlyTg0_r1 @0 {
       bits 7;
       access rw;
       reset 7'h0;
    }
  }
  register RxPBDlyTg1_r1 @'h169 {
    field RxPBDlyTg1_r1 @0 {
       bits 7;
       access rw;
       reset 7'h0;
    }
  }
  register RxPBDlyTg2_r1 @'h16a {
    field RxPBDlyTg2_r1 @0 {
       bits 7;
       access rw;
       reset 7'h0;
    }
  }
  register RxPBDlyTg3_r1 @'h16b {
    field RxPBDlyTg3_r1 @0 {
       bits 7;
       access rw;
       reset 7'h0;
    }
  }
  register RxEnDlyTg0_u1_p0 @'h180 {
    field RxEnDlyTg0_u1_p0 @0 {
       bits 11;
       access rw;
       reset 11'h100;
    }
  }
  register RxEnDlyTg1_u1_p0 @'h181 {
    field RxEnDlyTg1_u1_p0 @0 {
       bits 11;
       access rw;
       reset 11'h100;
    }
  }
  register RxEnDlyTg2_u1_p0 @'h182 {
    field RxEnDlyTg2_u1_p0 @0 {
       bits 11;
       access rw;
       reset 11'h100;
    }
  }
  register RxEnDlyTg3_u1_p0 @'h183 {
    field RxEnDlyTg3_u1_p0 @0 {
       bits 11;
       access rw;
       reset 11'h100;
    }
  }
  register RxClkDlyTg0_u1_p0 @'h18c {
    field RxClkDlyTg0_u1_p0 @0 {
       bits 6;
       access rw;
       reset 6'h10;
    }
  }
  register RxClkDlyTg1_u1_p0 @'h18d {
    field RxClkDlyTg1_u1_p0 @0 {
       bits 6;
       access rw;
       reset 6'h10;
    }
  }
  register RxClkDlyTg2_u1_p0 @'h18e {
    field RxClkDlyTg2_u1_p0 @0 {
       bits 6;
       access rw;
       reset 6'h10;
    }
  }
  register RxClkDlyTg3_u1_p0 @'h18f {
    field RxClkDlyTg3_u1_p0 @0 {
       bits 6;
       access rw;
       reset 6'h10;
    }
  }
  register RxClkcDlyTg0_u1_p0 @'h190 {
    field RxClkcDlyTg0_u1_p0 @0 {
       bits 6;
       access rw;
       reset 6'h10;
    }
  }
  register RxClkcDlyTg1_u1_p0 @'h191 {
    field RxClkcDlyTg1_u1_p0 @0 {
       bits 6;
       access rw;
       reset 6'h10;
    }
  }
  register RxClkcDlyTg2_u1_p0 @'h192 {
    field RxClkcDlyTg2_u1_p0 @0 {
       bits 6;
       access rw;
       reset 6'h10;
    }
  }
  register RxClkcDlyTg3_u1_p0 @'h193 {
    field RxClkcDlyTg3_u1_p0 @0 {
       bits 6;
       access rw;
       reset 6'h10;
    }
  }
  register Tsm0_i1 @'h1b2 {
    field RFU_Tsm0_i1 @0 {
       bits 14;
       access rw;
       reset 14'h0;
    }
  }
  register Tsm1_i1 @'h1b3 {
    field RFU_Tsm1_i1 @0 {
       bits 16;
       access ro;
       reset 16'h0;
    }
  }
  register Tsm2_i1 @'h1b4 {
    field RFU_Tsm2_i1 @0 {
       bits 1;
       access rw;
       reset 1'h0;
    }
  }
  register TxDqDlyTg0_r1_p0 @'h1c0 {
    field TxDqDlyTg0_r1_p0 @0 {
       bits 9;
       access rw;
       reset 9'h10;
    }
  }
  register TxDqDlyTg1_r1_p0 @'h1c1 {
    field TxDqDlyTg1_r1_p0 @0 {
       bits 9;
       access rw;
       reset 9'h10;
    }
  }
  register TxDqDlyTg2_r1_p0 @'h1c2 {
    field TxDqDlyTg2_r1_p0 @0 {
       bits 9;
       access rw;
       reset 9'h10;
    }
  }
  register TxDqDlyTg3_r1_p0 @'h1c3 {
    field TxDqDlyTg3_r1_p0 @0 {
       bits 9;
       access rw;
       reset 9'h10;
    }
  }
  register TxDqsDlyTg0_u1_p0 @'h1d0 {
    field TxDqsDlyTg0_u1_p0 @0 {
       bits 10;
       access rw;
       reset 10'h100;
    }
  }
  register TxDqsDlyTg1_u1_p0 @'h1d1 {
    field TxDqsDlyTg1_u1_p0 @0 {
       bits 10;
       access rw;
       reset 10'h100;
    }
  }
  register TxDqsDlyTg2_u1_p0 @'h1d2 {
    field TxDqsDlyTg2_u1_p0 @0 {
       bits 10;
       access rw;
       reset 10'h100;
    }
  }
  register TxDqsDlyTg3_u1_p0 @'h1d3 {
    field TxDqsDlyTg3_u1_p0 @0 {
       bits 10;
       access rw;
       reset 10'h100;
    }
  }
  register VrefDAC1_r2 @'h230 {
    field VrefDAC1_r2 @0 {
       bits 7;
       access rw;
       reset 7'h0;
    }
  }
  register TrainingCntr_r2 @'h232 {
    field RFU_TrainingCntr_r2 @0 {
       bits 16;
       access rw;
       reset 16'h0;
    }
  }
  register VrefDAC0_r2 @'h240 {
    field VrefDAC0_r2 @0 {
       bits 7;
       access rw;
       reset 7'h0;
    }
  }
  register TrainingIncDecDtsmEn_r2 @'h262 {
    field TrainingIncDecDtsmEn_r2 @0 {
       bits 9;
       access rw;
       reset 9'h0;
    }
  }
  register RxPBDlyTg0_r2 @'h268 {
    field RxPBDlyTg0_r2 @0 {
       bits 7;
       access rw;
       reset 7'h0;
    }
  }
  register RxPBDlyTg1_r2 @'h269 {
    field RxPBDlyTg1_r2 @0 {
       bits 7;
       access rw;
       reset 7'h0;
    }
  }
  register RxPBDlyTg2_r2 @'h26a {
    field RxPBDlyTg2_r2 @0 {
       bits 7;
       access rw;
       reset 7'h0;
    }
  }
  register RxPBDlyTg3_r2 @'h26b {
    field RxPBDlyTg3_r2 @0 {
       bits 7;
       access rw;
       reset 7'h0;
    }
  }
  register Tsm0_i2 @'h2b2 {
    field RFU_Tsm0_i2 @0 {
       bits 14;
       access rw;
       reset 14'h0;
    }
  }
  register Tsm1_i2 @'h2b3 {
    field RFU_Tsm1_i2 @0 {
       bits 16;
       access ro;
       reset 16'h0;
    }
  }
  register Tsm2_i2 @'h2b4 {
    field RFU_Tsm2_i2 @0 {
       bits 1;
       access rw;
       reset 1'h0;
    }
  }
  register TxDqDlyTg0_r2_p0 @'h2c0 {
    field TxDqDlyTg0_r2_p0 @0 {
       bits 9;
       access rw;
       reset 9'h10;
    }
  }
  register TxDqDlyTg1_r2_p0 @'h2c1 {
    field TxDqDlyTg1_r2_p0 @0 {
       bits 9;
       access rw;
       reset 9'h10;
    }
  }
  register TxDqDlyTg2_r2_p0 @'h2c2 {
    field TxDqDlyTg2_r2_p0 @0 {
       bits 9;
       access rw;
       reset 9'h10;
    }
  }
  register TxDqDlyTg3_r2_p0 @'h2c3 {
    field TxDqDlyTg3_r2_p0 @0 {
       bits 9;
       access rw;
       reset 9'h10;
    }
  }
  register VrefDAC1_r3 @'h330 {
    field VrefDAC1_r3 @0 {
       bits 7;
       access rw;
       reset 7'h0;
    }
  }
  register TrainingCntr_r3 @'h332 {
    field RFU_TrainingCntr_r3 @0 {
       bits 16;
       access rw;
       reset 16'h0;
    }
  }
  register VrefDAC0_r3 @'h340 {
    field VrefDAC0_r3 @0 {
       bits 7;
       access rw;
       reset 7'h0;
    }
  }
  register TrainingIncDecDtsmEn_r3 @'h362 {
    field TrainingIncDecDtsmEn_r3 @0 {
       bits 9;
       access rw;
       reset 9'h0;
    }
  }
  register RxPBDlyTg0_r3 @'h368 {
    field RxPBDlyTg0_r3 @0 {
       bits 7;
       access rw;
       reset 7'h0;
    }
  }
  register RxPBDlyTg1_r3 @'h369 {
    field RxPBDlyTg1_r3 @0 {
       bits 7;
       access rw;
       reset 7'h0;
    }
  }
  register RxPBDlyTg2_r3 @'h36a {
    field RxPBDlyTg2_r3 @0 {
       bits 7;
       access rw;
       reset 7'h0;
    }
  }
  register RxPBDlyTg3_r3 @'h36b {
    field RxPBDlyTg3_r3 @0 {
       bits 7;
       access rw;
       reset 7'h0;
    }
  }
  register Tsm0_i3 @'h3b2 {
    field RFU_Tsm0_i3 @0 {
       bits 14;
       access rw;
       reset 14'h0;
    }
  }
  register Tsm1_i3 @'h3b3 {
    field RFU_Tsm1_i3 @0 {
       bits 16;
       access ro;
       reset 16'h0;
    }
  }
  register Tsm2_i3 @'h3b4 {
    field RFU_Tsm2_i3 @0 {
       bits 1;
       access rw;
       reset 1'h0;
    }
  }
  register TxDqDlyTg0_r3_p0 @'h3c0 {
    field TxDqDlyTg0_r3_p0 @0 {
       bits 9;
       access rw;
       reset 9'h10;
    }
  }
  register TxDqDlyTg1_r3_p0 @'h3c1 {
    field TxDqDlyTg1_r3_p0 @0 {
       bits 9;
       access rw;
       reset 9'h10;
    }
  }
  register TxDqDlyTg2_r3_p0 @'h3c2 {
    field TxDqDlyTg2_r3_p0 @0 {
       bits 9;
       access rw;
       reset 9'h10;
    }
  }
  register TxDqDlyTg3_r3_p0 @'h3c3 {
    field TxDqDlyTg3_r3_p0 @0 {
       bits 9;
       access rw;
       reset 9'h10;
    }
  }
  register VrefDAC1_r4 @'h430 {
    field VrefDAC1_r4 @0 {
       bits 7;
       access rw;
       reset 7'h0;
    }
  }
  register TrainingCntr_r4 @'h432 {
    field RFU_TrainingCntr_r4 @0 {
       bits 16;
       access rw;
       reset 16'h0;
    }
  }
  register VrefDAC0_r4 @'h440 {
    field VrefDAC0_r4 @0 {
       bits 7;
       access rw;
       reset 7'h0;
    }
  }
  register TrainingIncDecDtsmEn_r4 @'h462 {
    field TrainingIncDecDtsmEn_r4 @0 {
       bits 9;
       access rw;
       reset 9'h0;
    }
  }
  register RxPBDlyTg0_r4 @'h468 {
    field RxPBDlyTg0_r4 @0 {
       bits 7;
       access rw;
       reset 7'h0;
    }
  }
  register RxPBDlyTg1_r4 @'h469 {
    field RxPBDlyTg1_r4 @0 {
       bits 7;
       access rw;
       reset 7'h0;
    }
  }
  register RxPBDlyTg2_r4 @'h46a {
    field RxPBDlyTg2_r4 @0 {
       bits 7;
       access rw;
       reset 7'h0;
    }
  }
  register RxPBDlyTg3_r4 @'h46b {
    field RxPBDlyTg3_r4 @0 {
       bits 7;
       access rw;
       reset 7'h0;
    }
  }
  register Tsm0_i4 @'h4b2 {
    field RFU_Tsm0_i4 @0 {
       bits 14;
       access rw;
       reset 14'h0;
    }
  }
  register Tsm1_i4 @'h4b3 {
    field RFU_Tsm1_i4 @0 {
       bits 16;
       access ro;
       reset 16'h0;
    }
  }
  register Tsm2_i4 @'h4b4 {
    field RFU_Tsm2_i4 @0 {
       bits 1;
       access rw;
       reset 1'h0;
    }
  }
  register TxDqDlyTg0_r4_p0 @'h4c0 {
    field TxDqDlyTg0_r4_p0 @0 {
       bits 9;
       access rw;
       reset 9'h10;
    }
  }
  register TxDqDlyTg1_r4_p0 @'h4c1 {
    field TxDqDlyTg1_r4_p0 @0 {
       bits 9;
       access rw;
       reset 9'h10;
    }
  }
  register TxDqDlyTg2_r4_p0 @'h4c2 {
    field TxDqDlyTg2_r4_p0 @0 {
       bits 9;
       access rw;
       reset 9'h10;
    }
  }
  register TxDqDlyTg3_r4_p0 @'h4c3 {
    field TxDqDlyTg3_r4_p0 @0 {
       bits 9;
       access rw;
       reset 9'h10;
    }
  }
  register VrefDAC1_r5 @'h530 {
    field VrefDAC1_r5 @0 {
       bits 7;
       access rw;
       reset 7'h0;
    }
  }
  register TrainingCntr_r5 @'h532 {
    field RFU_TrainingCntr_r5 @0 {
       bits 16;
       access rw;
       reset 16'h0;
    }
  }
  register VrefDAC0_r5 @'h540 {
    field VrefDAC0_r5 @0 {
       bits 7;
       access rw;
       reset 7'h0;
    }
  }
  register TrainingIncDecDtsmEn_r5 @'h562 {
    field TrainingIncDecDtsmEn_r5 @0 {
       bits 9;
       access rw;
       reset 9'h0;
    }
  }
  register RxPBDlyTg0_r5 @'h568 {
    field RxPBDlyTg0_r5 @0 {
       bits 7;
       access rw;
       reset 7'h0;
    }
  }
  register RxPBDlyTg1_r5 @'h569 {
    field RxPBDlyTg1_r5 @0 {
       bits 7;
       access rw;
       reset 7'h0;
    }
  }
  register RxPBDlyTg2_r5 @'h56a {
    field RxPBDlyTg2_r5 @0 {
       bits 7;
       access rw;
       reset 7'h0;
    }
  }
  register RxPBDlyTg3_r5 @'h56b {
    field RxPBDlyTg3_r5 @0 {
       bits 7;
       access rw;
       reset 7'h0;
    }
  }
  register Tsm0_i5 @'h5b2 {
    field RFU_Tsm0_i5 @0 {
       bits 14;
       access rw;
       reset 14'h0;
    }
  }
  register Tsm1_i5 @'h5b3 {
    field RFU_Tsm1_i5 @0 {
       bits 16;
       access ro;
       reset 16'h0;
    }
  }
  register Tsm2_i5 @'h5b4 {
    field RFU_Tsm2_i5 @0 {
       bits 1;
       access rw;
       reset 1'h0;
    }
  }
  register TxDqDlyTg0_r5_p0 @'h5c0 {
    field TxDqDlyTg0_r5_p0 @0 {
       bits 9;
       access rw;
       reset 9'h10;
    }
  }
  register TxDqDlyTg1_r5_p0 @'h5c1 {
    field TxDqDlyTg1_r5_p0 @0 {
       bits 9;
       access rw;
       reset 9'h10;
    }
  }
  register TxDqDlyTg2_r5_p0 @'h5c2 {
    field TxDqDlyTg2_r5_p0 @0 {
       bits 9;
       access rw;
       reset 9'h10;
    }
  }
  register TxDqDlyTg3_r5_p0 @'h5c3 {
    field TxDqDlyTg3_r5_p0 @0 {
       bits 9;
       access rw;
       reset 9'h10;
    }
  }
  register VrefDAC1_r6 @'h630 {
    field VrefDAC1_r6 @0 {
       bits 7;
       access rw;
       reset 7'h0;
    }
  }
  register TrainingCntr_r6 @'h632 {
    field RFU_TrainingCntr_r6 @0 {
       bits 16;
       access rw;
       reset 16'h0;
    }
  }
  register VrefDAC0_r6 @'h640 {
    field VrefDAC0_r6 @0 {
       bits 7;
       access rw;
       reset 7'h0;
    }
  }
  register TrainingIncDecDtsmEn_r6 @'h662 {
    field TrainingIncDecDtsmEn_r6 @0 {
       bits 9;
       access rw;
       reset 9'h0;
    }
  }
  register RxPBDlyTg0_r6 @'h668 {
    field RxPBDlyTg0_r6 @0 {
       bits 7;
       access rw;
       reset 7'h0;
    }
  }
  register RxPBDlyTg1_r6 @'h669 {
    field RxPBDlyTg1_r6 @0 {
       bits 7;
       access rw;
       reset 7'h0;
    }
  }
  register RxPBDlyTg2_r6 @'h66a {
    field RxPBDlyTg2_r6 @0 {
       bits 7;
       access rw;
       reset 7'h0;
    }
  }
  register RxPBDlyTg3_r6 @'h66b {
    field RxPBDlyTg3_r6 @0 {
       bits 7;
       access rw;
       reset 7'h0;
    }
  }
  register Tsm0_i6 @'h6b2 {
    field RFU_Tsm0_i6 @0 {
       bits 14;
       access rw;
       reset 14'h0;
    }
  }
  register Tsm1_i6 @'h6b3 {
    field RFU_Tsm1_i6 @0 {
       bits 16;
       access ro;
       reset 16'h0;
    }
  }
  register Tsm2_i6 @'h6b4 {
    field RFU_Tsm2_i6 @0 {
       bits 1;
       access rw;
       reset 1'h0;
    }
  }
  register TxDqDlyTg0_r6_p0 @'h6c0 {
    field TxDqDlyTg0_r6_p0 @0 {
       bits 9;
       access rw;
       reset 9'h10;
    }
  }
  register TxDqDlyTg1_r6_p0 @'h6c1 {
    field TxDqDlyTg1_r6_p0 @0 {
       bits 9;
       access rw;
       reset 9'h10;
    }
  }
  register TxDqDlyTg2_r6_p0 @'h6c2 {
    field TxDqDlyTg2_r6_p0 @0 {
       bits 9;
       access rw;
       reset 9'h10;
    }
  }
  register TxDqDlyTg3_r6_p0 @'h6c3 {
    field TxDqDlyTg3_r6_p0 @0 {
       bits 9;
       access rw;
       reset 9'h10;
    }
  }
  register VrefDAC1_r7 @'h730 {
    field VrefDAC1_r7 @0 {
       bits 7;
       access rw;
       reset 7'h0;
    }
  }
  register TrainingCntr_r7 @'h732 {
    field RFU_TrainingCntr_r7 @0 {
       bits 16;
       access rw;
       reset 16'h0;
    }
  }
  register VrefDAC0_r7 @'h740 {
    field VrefDAC0_r7 @0 {
       bits 7;
       access rw;
       reset 7'h0;
    }
  }
  register TrainingIncDecDtsmEn_r7 @'h762 {
    field TrainingIncDecDtsmEn_r7 @0 {
       bits 9;
       access rw;
       reset 9'h0;
    }
  }
  register RxPBDlyTg0_r7 @'h768 {
    field RxPBDlyTg0_r7 @0 {
       bits 7;
       access rw;
       reset 7'h0;
    }
  }
  register RxPBDlyTg1_r7 @'h769 {
    field RxPBDlyTg1_r7 @0 {
       bits 7;
       access rw;
       reset 7'h0;
    }
  }
  register RxPBDlyTg2_r7 @'h76a {
    field RxPBDlyTg2_r7 @0 {
       bits 7;
       access rw;
       reset 7'h0;
    }
  }
  register RxPBDlyTg3_r7 @'h76b {
    field RxPBDlyTg3_r7 @0 {
       bits 7;
       access rw;
       reset 7'h0;
    }
  }
  register Tsm0_i7 @'h7b2 {
    field RFU_Tsm0_i7 @0 {
       bits 14;
       access rw;
       reset 14'h0;
    }
  }
  register Tsm1_i7 @'h7b3 {
    field RFU_Tsm1_i7 @0 {
       bits 16;
       access ro;
       reset 16'h0;
    }
  }
  register Tsm2_i7 @'h7b4 {
    field RFU_Tsm2_i7 @0 {
       bits 1;
       access rw;
       reset 1'h0;
    }
  }
  register TxDqDlyTg0_r7_p0 @'h7c0 {
    field TxDqDlyTg0_r7_p0 @0 {
       bits 9;
       access rw;
       reset 9'h10;
    }
  }
  register TxDqDlyTg1_r7_p0 @'h7c1 {
    field TxDqDlyTg1_r7_p0 @0 {
       bits 9;
       access rw;
       reset 9'h10;
    }
  }
  register TxDqDlyTg2_r7_p0 @'h7c2 {
    field TxDqDlyTg2_r7_p0 @0 {
       bits 9;
       access rw;
       reset 9'h10;
    }
  }
  register TxDqDlyTg3_r7_p0 @'h7c3 {
    field TxDqDlyTg3_r7_p0 @0 {
       bits 9;
       access rw;
       reset 9'h10;
    }
  }
  register VrefDAC1_r8 @'h830 {
    field VrefDAC1_r8 @0 {
       bits 7;
       access rw;
       reset 7'h0;
    }
  }
  register TrainingCntr_r8 @'h832 {
    field RFU_TrainingCntr_r8 @0 {
       bits 16;
       access rw;
       reset 16'h0;
    }
  }
  register VrefDAC0_r8 @'h840 {
    field VrefDAC0_r8 @0 {
       bits 7;
       access rw;
       reset 7'h0;
    }
  }
  register TrainingIncDecDtsmEn_r8 @'h862 {
    field TrainingIncDecDtsmEn_r8 @0 {
       bits 9;
       access rw;
       reset 9'h0;
    }
  }
  register RxPBDlyTg0_r8 @'h868 {
    field RxPBDlyTg0_r8 @0 {
       bits 7;
       access rw;
       reset 7'h0;
    }
  }
  register RxPBDlyTg1_r8 @'h869 {
    field RxPBDlyTg1_r8 @0 {
       bits 7;
       access rw;
       reset 7'h0;
    }
  }
  register RxPBDlyTg2_r8 @'h86a {
    field RxPBDlyTg2_r8 @0 {
       bits 7;
       access rw;
       reset 7'h0;
    }
  }
  register RxPBDlyTg3_r8 @'h86b {
    field RxPBDlyTg3_r8 @0 {
       bits 7;
       access rw;
       reset 7'h0;
    }
  }
  register Tsm0_i8 @'h8b2 {
    field RFU_Tsm0_i8 @0 {
       bits 14;
       access rw;
       reset 14'h0;
    }
  }
  register Tsm1_i8 @'h8b3 {
    field RFU_Tsm1_i8 @0 {
       bits 16;
       access ro;
       reset 16'h0;
    }
  }
  register Tsm2_i8 @'h8b4 {
    field RFU_Tsm2_i8 @0 {
       bits 1;
       access rw;
       reset 1'h0;
    }
  }
  register TxDqDlyTg0_r8_p0 @'h8c0 {
    field TxDqDlyTg0_r8_p0 @0 {
       bits 9;
       access rw;
       reset 9'h10;
    }
  }
  register TxDqDlyTg1_r8_p0 @'h8c1 {
    field TxDqDlyTg1_r8_p0 @0 {
       bits 9;
       access rw;
       reset 9'h10;
    }
  }
  register TxDqDlyTg2_r8_p0 @'h8c2 {
    field TxDqDlyTg2_r8_p0 @0 {
       bits 9;
       access rw;
       reset 9'h10;
    }
  }
  register TxDqDlyTg3_r8_p0 @'h8c3 {
    field TxDqDlyTg3_r8_p0 @0 {
       bits 9;
       access rw;
       reset 9'h10;
    }
  }
  register UseDqsEnReplica_p1 @'h100003 {
    field UseDqsEnReplica_p1 @0 {
       bits 1;
       access rw;
       reset 1'h0;
    }
  }
  register DFIMRL_p1 @'h100020 {
    field DFIMRL_p1 @0 {
       bits 5;
       access rw;
       reset 5'h6;
    }
  }
  register TxImpedanceCtrl0_b0_p1 @'h100041 {
    field DrvStrenDqP @0 {
       bits 6;
       access rw;
       reset 6'h3f;
    }
    field DrvStrenDqN @6 {
       bits 6;
       access rw;
       reset 6'h3f;
    }
  }
  register DqDqsRcvCntrl_b0_p1 @'h100043 {
    field SelAnalogVref @0 {
       bits 1;
       access rw;
       reset 1'h0;
    }
    field ExtVrefRange @1 {
       bits 1;
       access rw;
       reset 1'h0;
    }
    field DfeCtrl @2 {
       bits 2;
       access rw;
       reset 2'h0;
    }
    field MajorModeDbyte @4 {
       bits 3;
       access rw;
       reset 3'h3;
    }
    field GainCurrAdj @7 {
       bits 5;
       access rw;
       reset 5'hb;
    }
    field Reserved @12 {
       bits 4;
    }
  }
  register TxEqualizationMode_p1 @'h100048 {
    field TxEqMode @0 {
       bits 2;
       access rw;
       reset 2'h0;
    }
  }
  register TxImpedanceCtrl1_b0_p1 @'h100049 {
    field DrvStrenFSDqP @0 {
       bits 6;
       access rw;
       reset 6'h3f;
    }
    field DrvStrenFSDqN @6 {
       bits 6;
       access rw;
       reset 6'h3f;
    }
  }
  register TxImpedanceCtrl2_b0_p1 @'h10004b {
    field DrvStrenEQHiDqP @0 {
       bits 6;
       access rw;
       reset 6'h0;
    }
    field DrvStrenEQLoDqN @6 {
       bits 6;
       access rw;
       reset 6'h0;
    }
  }
  register DqDqsRcvCntrl2_p1 @'h10004c {
    field EnRxAgressivePDR @0 {
       bits 1;
       access rw;
       reset 1'h0;
    }
  }
  register TxOdtDrvStren_b0_p1 @'h10004d {
    field ODTStrenP @0 {
       bits 6;
       access rw;
       reset 6'h0;
    }
    field ODTStrenN @6 {
       bits 6;
       access rw;
       reset 6'h0;
    }
  }
  register TxSlewRate_b0_p1 @'h10005f {
    field TxPreP @0 {
       bits 4;
       access rw;
       reset 4'hf;
    }
    field TxPreN @4 {
       bits 4;
       access rw;
       reset 4'hf;
    }
    field TxPreDrvMode @8 {
       bits 3;
       access rw;
       reset 3'h7;
    }
  }
  register RxEnDlyTg0_u0_p1 @'h100080 {
    field RxEnDlyTg0_u0_p1 @0 {
       bits 11;
       access rw;
       reset 11'h100;
    }
  }
  register RxEnDlyTg1_u0_p1 @'h100081 {
    field RxEnDlyTg1_u0_p1 @0 {
       bits 11;
       access rw;
       reset 11'h100;
    }
  }
  register RxEnDlyTg2_u0_p1 @'h100082 {
    field RxEnDlyTg2_u0_p1 @0 {
       bits 11;
       access rw;
       reset 11'h100;
    }
  }
  register RxEnDlyTg3_u0_p1 @'h100083 {
    field RxEnDlyTg3_u0_p1 @0 {
       bits 11;
       access rw;
       reset 11'h100;
    }
  }
  register RxClkDlyTg0_u0_p1 @'h10008c {
    field RxClkDlyTg0_u0_p1 @0 {
       bits 6;
       access rw;
       reset 6'h10;
    }
  }
  register RxClkDlyTg1_u0_p1 @'h10008d {
    field RxClkDlyTg1_u0_p1 @0 {
       bits 6;
       access rw;
       reset 6'h10;
    }
  }
  register RxClkDlyTg2_u0_p1 @'h10008e {
    field RxClkDlyTg2_u0_p1 @0 {
       bits 6;
       access rw;
       reset 6'h10;
    }
  }
  register RxClkDlyTg3_u0_p1 @'h10008f {
    field RxClkDlyTg3_u0_p1 @0 {
       bits 6;
       access rw;
       reset 6'h10;
    }
  }
  register RxClkcDlyTg0_u0_p1 @'h100090 {
    field RxClkcDlyTg0_u0_p1 @0 {
       bits 6;
       access rw;
       reset 6'h10;
    }
  }
  register RxClkcDlyTg1_u0_p1 @'h100091 {
    field RxClkcDlyTg1_u0_p1 @0 {
       bits 6;
       access rw;
       reset 6'h10;
    }
  }
  register RxClkcDlyTg2_u0_p1 @'h100092 {
    field RxClkcDlyTg2_u0_p1 @0 {
       bits 6;
       access rw;
       reset 6'h10;
    }
  }
  register RxClkcDlyTg3_u0_p1 @'h100093 {
    field RxClkcDlyTg3_u0_p1 @0 {
       bits 6;
       access rw;
       reset 6'h10;
    }
  }
  register PptDqsCntInvTrnTg0_p1 @'h1000ae {
    field PptDqsCntInvTrnTg0_p1 @0 {
       bits 16;
       access rw;
       reset 16'h0;
    }
  }
  register PptDqsCntInvTrnTg1_p1 @'h1000af {
    field PptDqsCntInvTrnTg1_p1 @0 {
       bits 16;
       access rw;
       reset 16'h0;
    }
  }
  register TxDqDlyTg0_r0_p1 @'h1000c0 {
    field TxDqDlyTg0_r0_p1 @0 {
       bits 9;
       access rw;
       reset 9'h10;
    }
  }
  register TxDqDlyTg1_r0_p1 @'h1000c1 {
    field TxDqDlyTg1_r0_p1 @0 {
       bits 9;
       access rw;
       reset 9'h10;
    }
  }
  register TxDqDlyTg2_r0_p1 @'h1000c2 {
    field TxDqDlyTg2_r0_p1 @0 {
       bits 9;
       access rw;
       reset 9'h10;
    }
  }
  register TxDqDlyTg3_r0_p1 @'h1000c3 {
    field TxDqDlyTg3_r0_p1 @0 {
       bits 9;
       access rw;
       reset 9'h10;
    }
  }
  register TxDqsDlyTg0_u0_p1 @'h1000d0 {
    field TxDqsDlyTg0_u0_p1 @0 {
       bits 10;
       access rw;
       reset 10'h100;
    }
  }
  register TxDqsDlyTg1_u0_p1 @'h1000d1 {
    field TxDqsDlyTg1_u0_p1 @0 {
       bits 10;
       access rw;
       reset 10'h100;
    }
  }
  register TxDqsDlyTg2_u0_p1 @'h1000d2 {
    field TxDqsDlyTg2_u0_p1 @0 {
       bits 10;
       access rw;
       reset 10'h100;
    }
  }
  register TxDqsDlyTg3_u0_p1 @'h1000d3 {
    field TxDqsDlyTg3_u0_p1 @0 {
       bits 10;
       access rw;
       reset 10'h100;
    }
  }
  register TxImpedanceCtrl0_b1_p1 @'h100141 {
    field DrvStrenDqP @0 {
       bits 6;
       access rw;
       reset 6'h3f;
    }
    field DrvStrenDqN @6 {
       bits 6;
       access rw;
       reset 6'h3f;
    }
  }
  register DqDqsRcvCntrl_b1_p1 @'h100143 {
    field SelAnalogVref @0 {
       bits 1;
       access rw;
       reset 1'h0;
    }
    field ExtVrefRange @1 {
       bits 1;
       access rw;
       reset 1'h0;
    }
    field DfeCtrl @2 {
       bits 2;
       access rw;
       reset 2'h0;
    }
    field MajorModeDbyte @4 {
       bits 3;
       access rw;
       reset 3'h3;
    }
    field GainCurrAdj @7 {
       bits 5;
       access rw;
       reset 5'hb;
    }
    field Reserved @12 {
       bits 4;
    }
  }
  register TxImpedanceCtrl1_b1_p1 @'h100149 {
    field DrvStrenFSDqP @0 {
       bits 6;
       access rw;
       reset 6'h3f;
    }
    field DrvStrenFSDqN @6 {
       bits 6;
       access rw;
       reset 6'h3f;
    }
  }
  register TxImpedanceCtrl2_b1_p1 @'h10014b {
    field DrvStrenEQHiDqP @0 {
       bits 6;
       access rw;
       reset 6'h0;
    }
    field DrvStrenEQLoDqN @6 {
       bits 6;
       access rw;
       reset 6'h0;
    }
  }
  register TxOdtDrvStren_b1_p1 @'h10014d {
    field ODTStrenP @0 {
       bits 6;
       access rw;
       reset 6'h0;
    }
    field ODTStrenN @6 {
       bits 6;
       access rw;
       reset 6'h0;
    }
  }
  register TxSlewRate_b1_p1 @'h10015f {
    field TxPreP @0 {
       bits 4;
       access rw;
       reset 4'hf;
    }
    field TxPreN @4 {
       bits 4;
       access rw;
       reset 4'hf;
    }
    field TxPreDrvMode @8 {
       bits 3;
       access rw;
       reset 3'h7;
    }
  }
  register RxEnDlyTg0_u1_p1 @'h100180 {
    field RxEnDlyTg0_u1_p1 @0 {
       bits 11;
       access rw;
       reset 11'h100;
    }
  }
  register RxEnDlyTg1_u1_p1 @'h100181 {
    field RxEnDlyTg1_u1_p1 @0 {
       bits 11;
       access rw;
       reset 11'h100;
    }
  }
  register RxEnDlyTg2_u1_p1 @'h100182 {
    field RxEnDlyTg2_u1_p1 @0 {
       bits 11;
       access rw;
       reset 11'h100;
    }
  }
  register RxEnDlyTg3_u1_p1 @'h100183 {
    field RxEnDlyTg3_u1_p1 @0 {
       bits 11;
       access rw;
       reset 11'h100;
    }
  }
  register RxClkDlyTg0_u1_p1 @'h10018c {
    field RxClkDlyTg0_u1_p1 @0 {
       bits 6;
       access rw;
       reset 6'h10;
    }
  }
  register RxClkDlyTg1_u1_p1 @'h10018d {
    field RxClkDlyTg1_u1_p1 @0 {
       bits 6;
       access rw;
       reset 6'h10;
    }
  }
  register RxClkDlyTg2_u1_p1 @'h10018e {
    field RxClkDlyTg2_u1_p1 @0 {
       bits 6;
       access rw;
       reset 6'h10;
    }
  }
  register RxClkDlyTg3_u1_p1 @'h10018f {
    field RxClkDlyTg3_u1_p1 @0 {
       bits 6;
       access rw;
       reset 6'h10;
    }
  }
  register RxClkcDlyTg0_u1_p1 @'h100190 {
    field RxClkcDlyTg0_u1_p1 @0 {
       bits 6;
       access rw;
       reset 6'h10;
    }
  }
  register RxClkcDlyTg1_u1_p1 @'h100191 {
    field RxClkcDlyTg1_u1_p1 @0 {
       bits 6;
       access rw;
       reset 6'h10;
    }
  }
  register RxClkcDlyTg2_u1_p1 @'h100192 {
    field RxClkcDlyTg2_u1_p1 @0 {
       bits 6;
       access rw;
       reset 6'h10;
    }
  }
  register RxClkcDlyTg3_u1_p1 @'h100193 {
    field RxClkcDlyTg3_u1_p1 @0 {
       bits 6;
       access rw;
       reset 6'h10;
    }
  }
  register TxDqDlyTg0_r1_p1 @'h1001c0 {
    field TxDqDlyTg0_r1_p1 @0 {
       bits 9;
       access rw;
       reset 9'h10;
    }
  }
  register TxDqDlyTg1_r1_p1 @'h1001c1 {
    field TxDqDlyTg1_r1_p1 @0 {
       bits 9;
       access rw;
       reset 9'h10;
    }
  }
  register TxDqDlyTg2_r1_p1 @'h1001c2 {
    field TxDqDlyTg2_r1_p1 @0 {
       bits 9;
       access rw;
       reset 9'h10;
    }
  }
  register TxDqDlyTg3_r1_p1 @'h1001c3 {
    field TxDqDlyTg3_r1_p1 @0 {
       bits 9;
       access rw;
       reset 9'h10;
    }
  }
  register TxDqsDlyTg0_u1_p1 @'h1001d0 {
    field TxDqsDlyTg0_u1_p1 @0 {
       bits 10;
       access rw;
       reset 10'h100;
    }
  }
  register TxDqsDlyTg1_u1_p1 @'h1001d1 {
    field TxDqsDlyTg1_u1_p1 @0 {
       bits 10;
       access rw;
       reset 10'h100;
    }
  }
  register TxDqsDlyTg2_u1_p1 @'h1001d2 {
    field TxDqsDlyTg2_u1_p1 @0 {
       bits 10;
       access rw;
       reset 10'h100;
    }
  }
  register TxDqsDlyTg3_u1_p1 @'h1001d3 {
    field TxDqsDlyTg3_u1_p1 @0 {
       bits 10;
       access rw;
       reset 10'h100;
    }
  }
  register TxDqDlyTg0_r2_p1 @'h1002c0 {
    field TxDqDlyTg0_r2_p1 @0 {
       bits 9;
       access rw;
       reset 9'h10;
    }
  }
  register TxDqDlyTg1_r2_p1 @'h1002c1 {
    field TxDqDlyTg1_r2_p1 @0 {
       bits 9;
       access rw;
       reset 9'h10;
    }
  }
  register TxDqDlyTg2_r2_p1 @'h1002c2 {
    field TxDqDlyTg2_r2_p1 @0 {
       bits 9;
       access rw;
       reset 9'h10;
    }
  }
  register TxDqDlyTg3_r2_p1 @'h1002c3 {
    field TxDqDlyTg3_r2_p1 @0 {
       bits 9;
       access rw;
       reset 9'h10;
    }
  }
  register TxDqDlyTg0_r3_p1 @'h1003c0 {
    field TxDqDlyTg0_r3_p1 @0 {
       bits 9;
       access rw;
       reset 9'h10;
    }
  }
  register TxDqDlyTg1_r3_p1 @'h1003c1 {
    field TxDqDlyTg1_r3_p1 @0 {
       bits 9;
       access rw;
       reset 9'h10;
    }
  }
  register TxDqDlyTg2_r3_p1 @'h1003c2 {
    field TxDqDlyTg2_r3_p1 @0 {
       bits 9;
       access rw;
       reset 9'h10;
    }
  }
  register TxDqDlyTg3_r3_p1 @'h1003c3 {
    field TxDqDlyTg3_r3_p1 @0 {
       bits 9;
       access rw;
       reset 9'h10;
    }
  }
  register TxDqDlyTg0_r4_p1 @'h1004c0 {
    field TxDqDlyTg0_r4_p1 @0 {
       bits 9;
       access rw;
       reset 9'h10;
    }
  }
  register TxDqDlyTg1_r4_p1 @'h1004c1 {
    field TxDqDlyTg1_r4_p1 @0 {
       bits 9;
       access rw;
       reset 9'h10;
    }
  }
  register TxDqDlyTg2_r4_p1 @'h1004c2 {
    field TxDqDlyTg2_r4_p1 @0 {
       bits 9;
       access rw;
       reset 9'h10;
    }
  }
  register TxDqDlyTg3_r4_p1 @'h1004c3 {
    field TxDqDlyTg3_r4_p1 @0 {
       bits 9;
       access rw;
       reset 9'h10;
    }
  }
  register TxDqDlyTg0_r5_p1 @'h1005c0 {
    field TxDqDlyTg0_r5_p1 @0 {
       bits 9;
       access rw;
       reset 9'h10;
    }
  }
  register TxDqDlyTg1_r5_p1 @'h1005c1 {
    field TxDqDlyTg1_r5_p1 @0 {
       bits 9;
       access rw;
       reset 9'h10;
    }
  }
  register TxDqDlyTg2_r5_p1 @'h1005c2 {
    field TxDqDlyTg2_r5_p1 @0 {
       bits 9;
       access rw;
       reset 9'h10;
    }
  }
  register TxDqDlyTg3_r5_p1 @'h1005c3 {
    field TxDqDlyTg3_r5_p1 @0 {
       bits 9;
       access rw;
       reset 9'h10;
    }
  }
  register TxDqDlyTg0_r6_p1 @'h1006c0 {
    field TxDqDlyTg0_r6_p1 @0 {
       bits 9;
       access rw;
       reset 9'h10;
    }
  }
  register TxDqDlyTg1_r6_p1 @'h1006c1 {
    field TxDqDlyTg1_r6_p1 @0 {
       bits 9;
       access rw;
       reset 9'h10;
    }
  }
  register TxDqDlyTg2_r6_p1 @'h1006c2 {
    field TxDqDlyTg2_r6_p1 @0 {
       bits 9;
       access rw;
       reset 9'h10;
    }
  }
  register TxDqDlyTg3_r6_p1 @'h1006c3 {
    field TxDqDlyTg3_r6_p1 @0 {
       bits 9;
       access rw;
       reset 9'h10;
    }
  }
  register TxDqDlyTg0_r7_p1 @'h1007c0 {
    field TxDqDlyTg0_r7_p1 @0 {
       bits 9;
       access rw;
       reset 9'h10;
    }
  }
  register TxDqDlyTg1_r7_p1 @'h1007c1 {
    field TxDqDlyTg1_r7_p1 @0 {
       bits 9;
       access rw;
       reset 9'h10;
    }
  }
  register TxDqDlyTg2_r7_p1 @'h1007c2 {
    field TxDqDlyTg2_r7_p1 @0 {
       bits 9;
       access rw;
       reset 9'h10;
    }
  }
  register TxDqDlyTg3_r7_p1 @'h1007c3 {
    field TxDqDlyTg3_r7_p1 @0 {
       bits 9;
       access rw;
       reset 9'h10;
    }
  }
  register TxDqDlyTg0_r8_p1 @'h1008c0 {
    field TxDqDlyTg0_r8_p1 @0 {
       bits 9;
       access rw;
       reset 9'h10;
    }
  }
  register TxDqDlyTg1_r8_p1 @'h1008c1 {
    field TxDqDlyTg1_r8_p1 @0 {
       bits 9;
       access rw;
       reset 9'h10;
    }
  }
  register TxDqDlyTg2_r8_p1 @'h1008c2 {
    field TxDqDlyTg2_r8_p1 @0 {
       bits 9;
       access rw;
       reset 9'h10;
    }
  }
  register TxDqDlyTg3_r8_p1 @'h1008c3 {
    field TxDqDlyTg3_r8_p1 @0 {
       bits 9;
       access rw;
       reset 9'h10;
    }
  }
  register UseDqsEnReplica_p2 @'h200003 {
    field UseDqsEnReplica_p2 @0 {
       bits 1;
       access rw;
       reset 1'h0;
    }
  }
  register DFIMRL_p2 @'h200020 {
    field DFIMRL_p2 @0 {
       bits 5;
       access rw;
       reset 5'h6;
    }
  }
  register TxImpedanceCtrl0_b0_p2 @'h200041 {
    field DrvStrenDqP @0 {
       bits 6;
       access rw;
       reset 6'h3f;
    }
    field DrvStrenDqN @6 {
       bits 6;
       access rw;
       reset 6'h3f;
    }
  }
  register DqDqsRcvCntrl_b0_p2 @'h200043 {
    field SelAnalogVref @0 {
       bits 1;
       access rw;
       reset 1'h0;
    }
    field ExtVrefRange @1 {
       bits 1;
       access rw;
       reset 1'h0;
    }
    field DfeCtrl @2 {
       bits 2;
       access rw;
       reset 2'h0;
    }
    field MajorModeDbyte @4 {
       bits 3;
       access rw;
       reset 3'h3;
    }
    field GainCurrAdj @7 {
       bits 5;
       access rw;
       reset 5'hb;
    }
    field Reserved @12 {
       bits 4;
    }
  }
  register TxEqualizationMode_p2 @'h200048 {
    field TxEqMode @0 {
       bits 2;
       access rw;
       reset 2'h0;
    }
  }
  register TxImpedanceCtrl1_b0_p2 @'h200049 {
    field DrvStrenFSDqP @0 {
       bits 6;
       access rw;
       reset 6'h3f;
    }
    field DrvStrenFSDqN @6 {
       bits 6;
       access rw;
       reset 6'h3f;
    }
  }
  register TxImpedanceCtrl2_b0_p2 @'h20004b {
    field DrvStrenEQHiDqP @0 {
       bits 6;
       access rw;
       reset 6'h0;
    }
    field DrvStrenEQLoDqN @6 {
       bits 6;
       access rw;
       reset 6'h0;
    }
  }
  register DqDqsRcvCntrl2_p2 @'h20004c {
    field EnRxAgressivePDR @0 {
       bits 1;
       access rw;
       reset 1'h0;
    }
  }
  register TxOdtDrvStren_b0_p2 @'h20004d {
    field ODTStrenP @0 {
       bits 6;
       access rw;
       reset 6'h0;
    }
    field ODTStrenN @6 {
       bits 6;
       access rw;
       reset 6'h0;
    }
  }
  register TxSlewRate_b0_p2 @'h20005f {
    field TxPreP @0 {
       bits 4;
       access rw;
       reset 4'hf;
    }
    field TxPreN @4 {
       bits 4;
       access rw;
       reset 4'hf;
    }
    field TxPreDrvMode @8 {
       bits 3;
       access rw;
       reset 3'h7;
    }
  }
  register RxEnDlyTg0_u0_p2 @'h200080 {
    field RxEnDlyTg0_u0_p2 @0 {
       bits 11;
       access rw;
       reset 11'h100;
    }
  }
  register RxEnDlyTg1_u0_p2 @'h200081 {
    field RxEnDlyTg1_u0_p2 @0 {
       bits 11;
       access rw;
       reset 11'h100;
    }
  }
  register RxEnDlyTg2_u0_p2 @'h200082 {
    field RxEnDlyTg2_u0_p2 @0 {
       bits 11;
       access rw;
       reset 11'h100;
    }
  }
  register RxEnDlyTg3_u0_p2 @'h200083 {
    field RxEnDlyTg3_u0_p2 @0 {
       bits 11;
       access rw;
       reset 11'h100;
    }
  }
  register RxClkDlyTg0_u0_p2 @'h20008c {
    field RxClkDlyTg0_u0_p2 @0 {
       bits 6;
       access rw;
       reset 6'h10;
    }
  }
  register RxClkDlyTg1_u0_p2 @'h20008d {
    field RxClkDlyTg1_u0_p2 @0 {
       bits 6;
       access rw;
       reset 6'h10;
    }
  }
  register RxClkDlyTg2_u0_p2 @'h20008e {
    field RxClkDlyTg2_u0_p2 @0 {
       bits 6;
       access rw;
       reset 6'h10;
    }
  }
  register RxClkDlyTg3_u0_p2 @'h20008f {
    field RxClkDlyTg3_u0_p2 @0 {
       bits 6;
       access rw;
       reset 6'h10;
    }
  }
  register RxClkcDlyTg0_u0_p2 @'h200090 {
    field RxClkcDlyTg0_u0_p2 @0 {
       bits 6;
       access rw;
       reset 6'h10;
    }
  }
  register RxClkcDlyTg1_u0_p2 @'h200091 {
    field RxClkcDlyTg1_u0_p2 @0 {
       bits 6;
       access rw;
       reset 6'h10;
    }
  }
  register RxClkcDlyTg2_u0_p2 @'h200092 {
    field RxClkcDlyTg2_u0_p2 @0 {
       bits 6;
       access rw;
       reset 6'h10;
    }
  }
  register RxClkcDlyTg3_u0_p2 @'h200093 {
    field RxClkcDlyTg3_u0_p2 @0 {
       bits 6;
       access rw;
       reset 6'h10;
    }
  }
  register PptDqsCntInvTrnTg0_p2 @'h2000ae {
    field PptDqsCntInvTrnTg0_p2 @0 {
       bits 16;
       access rw;
       reset 16'h0;
    }
  }
  register PptDqsCntInvTrnTg1_p2 @'h2000af {
    field PptDqsCntInvTrnTg1_p2 @0 {
       bits 16;
       access rw;
       reset 16'h0;
    }
  }
  register TxDqDlyTg0_r0_p2 @'h2000c0 {
    field TxDqDlyTg0_r0_p2 @0 {
       bits 9;
       access rw;
       reset 9'h10;
    }
  }
  register TxDqDlyTg1_r0_p2 @'h2000c1 {
    field TxDqDlyTg1_r0_p2 @0 {
       bits 9;
       access rw;
       reset 9'h10;
    }
  }
  register TxDqDlyTg2_r0_p2 @'h2000c2 {
    field TxDqDlyTg2_r0_p2 @0 {
       bits 9;
       access rw;
       reset 9'h10;
    }
  }
  register TxDqDlyTg3_r0_p2 @'h2000c3 {
    field TxDqDlyTg3_r0_p2 @0 {
       bits 9;
       access rw;
       reset 9'h10;
    }
  }
  register TxDqsDlyTg0_u0_p2 @'h2000d0 {
    field TxDqsDlyTg0_u0_p2 @0 {
       bits 10;
       access rw;
       reset 10'h100;
    }
  }
  register TxDqsDlyTg1_u0_p2 @'h2000d1 {
    field TxDqsDlyTg1_u0_p2 @0 {
       bits 10;
       access rw;
       reset 10'h100;
    }
  }
  register TxDqsDlyTg2_u0_p2 @'h2000d2 {
    field TxDqsDlyTg2_u0_p2 @0 {
       bits 10;
       access rw;
       reset 10'h100;
    }
  }
  register TxDqsDlyTg3_u0_p2 @'h2000d3 {
    field TxDqsDlyTg3_u0_p2 @0 {
       bits 10;
       access rw;
       reset 10'h100;
    }
  }
  register TxImpedanceCtrl0_b1_p2 @'h200141 {
    field DrvStrenDqP @0 {
       bits 6;
       access rw;
       reset 6'h3f;
    }
    field DrvStrenDqN @6 {
       bits 6;
       access rw;
       reset 6'h3f;
    }
  }
  register DqDqsRcvCntrl_b1_p2 @'h200143 {
    field SelAnalogVref @0 {
       bits 1;
       access rw;
       reset 1'h0;
    }
    field ExtVrefRange @1 {
       bits 1;
       access rw;
       reset 1'h0;
    }
    field DfeCtrl @2 {
       bits 2;
       access rw;
       reset 2'h0;
    }
    field MajorModeDbyte @4 {
       bits 3;
       access rw;
       reset 3'h3;
    }
    field GainCurrAdj @7 {
       bits 5;
       access rw;
       reset 5'hb;
    }
    field Reserved @12 {
       bits 4;
    }
  }
  register TxImpedanceCtrl1_b1_p2 @'h200149 {
    field DrvStrenFSDqP @0 {
       bits 6;
       access rw;
       reset 6'h3f;
    }
    field DrvStrenFSDqN @6 {
       bits 6;
       access rw;
       reset 6'h3f;
    }
  }
  register TxImpedanceCtrl2_b1_p2 @'h20014b {
    field DrvStrenEQHiDqP @0 {
       bits 6;
       access rw;
       reset 6'h0;
    }
    field DrvStrenEQLoDqN @6 {
       bits 6;
       access rw;
       reset 6'h0;
    }
  }
  register TxOdtDrvStren_b1_p2 @'h20014d {
    field ODTStrenP @0 {
       bits 6;
       access rw;
       reset 6'h0;
    }
    field ODTStrenN @6 {
       bits 6;
       access rw;
       reset 6'h0;
    }
  }
  register TxSlewRate_b1_p2 @'h20015f {
    field TxPreP @0 {
       bits 4;
       access rw;
       reset 4'hf;
    }
    field TxPreN @4 {
       bits 4;
       access rw;
       reset 4'hf;
    }
    field TxPreDrvMode @8 {
       bits 3;
       access rw;
       reset 3'h7;
    }
  }
  register RxEnDlyTg0_u1_p2 @'h200180 {
    field RxEnDlyTg0_u1_p2 @0 {
       bits 11;
       access rw;
       reset 11'h100;
    }
  }
  register RxEnDlyTg1_u1_p2 @'h200181 {
    field RxEnDlyTg1_u1_p2 @0 {
       bits 11;
       access rw;
       reset 11'h100;
    }
  }
  register RxEnDlyTg2_u1_p2 @'h200182 {
    field RxEnDlyTg2_u1_p2 @0 {
       bits 11;
       access rw;
       reset 11'h100;
    }
  }
  register RxEnDlyTg3_u1_p2 @'h200183 {
    field RxEnDlyTg3_u1_p2 @0 {
       bits 11;
       access rw;
       reset 11'h100;
    }
  }
  register RxClkDlyTg0_u1_p2 @'h20018c {
    field RxClkDlyTg0_u1_p2 @0 {
       bits 6;
       access rw;
       reset 6'h10;
    }
  }
  register RxClkDlyTg1_u1_p2 @'h20018d {
    field RxClkDlyTg1_u1_p2 @0 {
       bits 6;
       access rw;
       reset 6'h10;
    }
  }
  register RxClkDlyTg2_u1_p2 @'h20018e {
    field RxClkDlyTg2_u1_p2 @0 {
       bits 6;
       access rw;
       reset 6'h10;
    }
  }
  register RxClkDlyTg3_u1_p2 @'h20018f {
    field RxClkDlyTg3_u1_p2 @0 {
       bits 6;
       access rw;
       reset 6'h10;
    }
  }
  register RxClkcDlyTg0_u1_p2 @'h200190 {
    field RxClkcDlyTg0_u1_p2 @0 {
       bits 6;
       access rw;
       reset 6'h10;
    }
  }
  register RxClkcDlyTg1_u1_p2 @'h200191 {
    field RxClkcDlyTg1_u1_p2 @0 {
       bits 6;
       access rw;
       reset 6'h10;
    }
  }
  register RxClkcDlyTg2_u1_p2 @'h200192 {
    field RxClkcDlyTg2_u1_p2 @0 {
       bits 6;
       access rw;
       reset 6'h10;
    }
  }
  register RxClkcDlyTg3_u1_p2 @'h200193 {
    field RxClkcDlyTg3_u1_p2 @0 {
       bits 6;
       access rw;
       reset 6'h10;
    }
  }
  register TxDqDlyTg0_r1_p2 @'h2001c0 {
    field TxDqDlyTg0_r1_p2 @0 {
       bits 9;
       access rw;
       reset 9'h10;
    }
  }
  register TxDqDlyTg1_r1_p2 @'h2001c1 {
    field TxDqDlyTg1_r1_p2 @0 {
       bits 9;
       access rw;
       reset 9'h10;
    }
  }
  register TxDqDlyTg2_r1_p2 @'h2001c2 {
    field TxDqDlyTg2_r1_p2 @0 {
       bits 9;
       access rw;
       reset 9'h10;
    }
  }
  register TxDqDlyTg3_r1_p2 @'h2001c3 {
    field TxDqDlyTg3_r1_p2 @0 {
       bits 9;
       access rw;
       reset 9'h10;
    }
  }
  register TxDqsDlyTg0_u1_p2 @'h2001d0 {
    field TxDqsDlyTg0_u1_p2 @0 {
       bits 10;
       access rw;
       reset 10'h100;
    }
  }
  register TxDqsDlyTg1_u1_p2 @'h2001d1 {
    field TxDqsDlyTg1_u1_p2 @0 {
       bits 10;
       access rw;
       reset 10'h100;
    }
  }
  register TxDqsDlyTg2_u1_p2 @'h2001d2 {
    field TxDqsDlyTg2_u1_p2 @0 {
       bits 10;
       access rw;
       reset 10'h100;
    }
  }
  register TxDqsDlyTg3_u1_p2 @'h2001d3 {
    field TxDqsDlyTg3_u1_p2 @0 {
       bits 10;
       access rw;
       reset 10'h100;
    }
  }
  register TxDqDlyTg0_r2_p2 @'h2002c0 {
    field TxDqDlyTg0_r2_p2 @0 {
       bits 9;
       access rw;
       reset 9'h10;
    }
  }
  register TxDqDlyTg1_r2_p2 @'h2002c1 {
    field TxDqDlyTg1_r2_p2 @0 {
       bits 9;
       access rw;
       reset 9'h10;
    }
  }
  register TxDqDlyTg2_r2_p2 @'h2002c2 {
    field TxDqDlyTg2_r2_p2 @0 {
       bits 9;
       access rw;
       reset 9'h10;
    }
  }
  register TxDqDlyTg3_r2_p2 @'h2002c3 {
    field TxDqDlyTg3_r2_p2 @0 {
       bits 9;
       access rw;
       reset 9'h10;
    }
  }
  register TxDqDlyTg0_r3_p2 @'h2003c0 {
    field TxDqDlyTg0_r3_p2 @0 {
       bits 9;
       access rw;
       reset 9'h10;
    }
  }
  register TxDqDlyTg1_r3_p2 @'h2003c1 {
    field TxDqDlyTg1_r3_p2 @0 {
       bits 9;
       access rw;
       reset 9'h10;
    }
  }
  register TxDqDlyTg2_r3_p2 @'h2003c2 {
    field TxDqDlyTg2_r3_p2 @0 {
       bits 9;
       access rw;
       reset 9'h10;
    }
  }
  register TxDqDlyTg3_r3_p2 @'h2003c3 {
    field TxDqDlyTg3_r3_p2 @0 {
       bits 9;
       access rw;
       reset 9'h10;
    }
  }
  register TxDqDlyTg0_r4_p2 @'h2004c0 {
    field TxDqDlyTg0_r4_p2 @0 {
       bits 9;
       access rw;
       reset 9'h10;
    }
  }
  register TxDqDlyTg1_r4_p2 @'h2004c1 {
    field TxDqDlyTg1_r4_p2 @0 {
       bits 9;
       access rw;
       reset 9'h10;
    }
  }
  register TxDqDlyTg2_r4_p2 @'h2004c2 {
    field TxDqDlyTg2_r4_p2 @0 {
       bits 9;
       access rw;
       reset 9'h10;
    }
  }
  register TxDqDlyTg3_r4_p2 @'h2004c3 {
    field TxDqDlyTg3_r4_p2 @0 {
       bits 9;
       access rw;
       reset 9'h10;
    }
  }
  register TxDqDlyTg0_r5_p2 @'h2005c0 {
    field TxDqDlyTg0_r5_p2 @0 {
       bits 9;
       access rw;
       reset 9'h10;
    }
  }
  register TxDqDlyTg1_r5_p2 @'h2005c1 {
    field TxDqDlyTg1_r5_p2 @0 {
       bits 9;
       access rw;
       reset 9'h10;
    }
  }
  register TxDqDlyTg2_r5_p2 @'h2005c2 {
    field TxDqDlyTg2_r5_p2 @0 {
       bits 9;
       access rw;
       reset 9'h10;
    }
  }
  register TxDqDlyTg3_r5_p2 @'h2005c3 {
    field TxDqDlyTg3_r5_p2 @0 {
       bits 9;
       access rw;
       reset 9'h10;
    }
  }
  register TxDqDlyTg0_r6_p2 @'h2006c0 {
    field TxDqDlyTg0_r6_p2 @0 {
       bits 9;
       access rw;
       reset 9'h10;
    }
  }
  register TxDqDlyTg1_r6_p2 @'h2006c1 {
    field TxDqDlyTg1_r6_p2 @0 {
       bits 9;
       access rw;
       reset 9'h10;
    }
  }
  register TxDqDlyTg2_r6_p2 @'h2006c2 {
    field TxDqDlyTg2_r6_p2 @0 {
       bits 9;
       access rw;
       reset 9'h10;
    }
  }
  register TxDqDlyTg3_r6_p2 @'h2006c3 {
    field TxDqDlyTg3_r6_p2 @0 {
       bits 9;
       access rw;
       reset 9'h10;
    }
  }
  register TxDqDlyTg0_r7_p2 @'h2007c0 {
    field TxDqDlyTg0_r7_p2 @0 {
       bits 9;
       access rw;
       reset 9'h10;
    }
  }
  register TxDqDlyTg1_r7_p2 @'h2007c1 {
    field TxDqDlyTg1_r7_p2 @0 {
       bits 9;
       access rw;
       reset 9'h10;
    }
  }
  register TxDqDlyTg2_r7_p2 @'h2007c2 {
    field TxDqDlyTg2_r7_p2 @0 {
       bits 9;
       access rw;
       reset 9'h10;
    }
  }
  register TxDqDlyTg3_r7_p2 @'h2007c3 {
    field TxDqDlyTg3_r7_p2 @0 {
       bits 9;
       access rw;
       reset 9'h10;
    }
  }
  register TxDqDlyTg0_r8_p2 @'h2008c0 {
    field TxDqDlyTg0_r8_p2 @0 {
       bits 9;
       access rw;
       reset 9'h10;
    }
  }
  register TxDqDlyTg1_r8_p2 @'h2008c1 {
    field TxDqDlyTg1_r8_p2 @0 {
       bits 9;
       access rw;
       reset 9'h10;
    }
  }
  register TxDqDlyTg2_r8_p2 @'h2008c2 {
    field TxDqDlyTg2_r8_p2 @0 {
       bits 9;
       access rw;
       reset 9'h10;
    }
  }
  register TxDqDlyTg3_r8_p2 @'h2008c3 {
    field TxDqDlyTg3_r8_p2 @0 {
       bits 9;
       access rw;
       reset 9'h10;
    }
  }
  register UseDqsEnReplica_p3 @'h300003 {
    field UseDqsEnReplica_p3 @0 {
       bits 1;
       access rw;
       reset 1'h0;
    }
  }
  register DFIMRL_p3 @'h300020 {
    field DFIMRL_p3 @0 {
       bits 5;
       access rw;
       reset 5'h6;
    }
  }
  register TxImpedanceCtrl0_b0_p3 @'h300041 {
    field DrvStrenDqP @0 {
       bits 6;
       access rw;
       reset 6'h3f;
    }
    field DrvStrenDqN @6 {
       bits 6;
       access rw;
       reset 6'h3f;
    }
  }
  register DqDqsRcvCntrl_b0_p3 @'h300043 {
    field SelAnalogVref @0 {
       bits 1;
       access rw;
       reset 1'h0;
    }
    field ExtVrefRange @1 {
       bits 1;
       access rw;
       reset 1'h0;
    }
    field DfeCtrl @2 {
       bits 2;
       access rw;
       reset 2'h0;
    }
    field MajorModeDbyte @4 {
       bits 3;
       access rw;
       reset 3'h3;
    }
    field GainCurrAdj @7 {
       bits 5;
       access rw;
       reset 5'hb;
    }
    field Reserved @12 {
       bits 4;
    }
  }
  register TxEqualizationMode_p3 @'h300048 {
    field TxEqMode @0 {
       bits 2;
       access rw;
       reset 2'h0;
    }
  }
  register TxImpedanceCtrl1_b0_p3 @'h300049 {
    field DrvStrenFSDqP @0 {
       bits 6;
       access rw;
       reset 6'h3f;
    }
    field DrvStrenFSDqN @6 {
       bits 6;
       access rw;
       reset 6'h3f;
    }
  }
  register TxImpedanceCtrl2_b0_p3 @'h30004b {
    field DrvStrenEQHiDqP @0 {
       bits 6;
       access rw;
       reset 6'h0;
    }
    field DrvStrenEQLoDqN @6 {
       bits 6;
       access rw;
       reset 6'h0;
    }
  }
  register DqDqsRcvCntrl2_p3 @'h30004c {
    field EnRxAgressivePDR @0 {
       bits 1;
       access rw;
       reset 1'h0;
    }
  }
  register TxOdtDrvStren_b0_p3 @'h30004d {
    field ODTStrenP @0 {
       bits 6;
       access rw;
       reset 6'h0;
    }
    field ODTStrenN @6 {
       bits 6;
       access rw;
       reset 6'h0;
    }
  }
  register TxSlewRate_b0_p3 @'h30005f {
    field TxPreP @0 {
       bits 4;
       access rw;
       reset 4'hf;
    }
    field TxPreN @4 {
       bits 4;
       access rw;
       reset 4'hf;
    }
    field TxPreDrvMode @8 {
       bits 3;
       access rw;
       reset 3'h7;
    }
  }
  register RxEnDlyTg0_u0_p3 @'h300080 {
    field RxEnDlyTg0_u0_p3 @0 {
       bits 11;
       access rw;
       reset 11'h100;
    }
  }
  register RxEnDlyTg1_u0_p3 @'h300081 {
    field RxEnDlyTg1_u0_p3 @0 {
       bits 11;
       access rw;
       reset 11'h100;
    }
  }
  register RxEnDlyTg2_u0_p3 @'h300082 {
    field RxEnDlyTg2_u0_p3 @0 {
       bits 11;
       access rw;
       reset 11'h100;
    }
  }
  register RxEnDlyTg3_u0_p3 @'h300083 {
    field RxEnDlyTg3_u0_p3 @0 {
       bits 11;
       access rw;
       reset 11'h100;
    }
  }
  register RxClkDlyTg0_u0_p3 @'h30008c {
    field RxClkDlyTg0_u0_p3 @0 {
       bits 6;
       access rw;
       reset 6'h10;
    }
  }
  register RxClkDlyTg1_u0_p3 @'h30008d {
    field RxClkDlyTg1_u0_p3 @0 {
       bits 6;
       access rw;
       reset 6'h10;
    }
  }
  register RxClkDlyTg2_u0_p3 @'h30008e {
    field RxClkDlyTg2_u0_p3 @0 {
       bits 6;
       access rw;
       reset 6'h10;
    }
  }
  register RxClkDlyTg3_u0_p3 @'h30008f {
    field RxClkDlyTg3_u0_p3 @0 {
       bits 6;
       access rw;
       reset 6'h10;
    }
  }
  register RxClkcDlyTg0_u0_p3 @'h300090 {
    field RxClkcDlyTg0_u0_p3 @0 {
       bits 6;
       access rw;
       reset 6'h10;
    }
  }
  register RxClkcDlyTg1_u0_p3 @'h300091 {
    field RxClkcDlyTg1_u0_p3 @0 {
       bits 6;
       access rw;
       reset 6'h10;
    }
  }
  register RxClkcDlyTg2_u0_p3 @'h300092 {
    field RxClkcDlyTg2_u0_p3 @0 {
       bits 6;
       access rw;
       reset 6'h10;
    }
  }
  register RxClkcDlyTg3_u0_p3 @'h300093 {
    field RxClkcDlyTg3_u0_p3 @0 {
       bits 6;
       access rw;
       reset 6'h10;
    }
  }
  register PptDqsCntInvTrnTg0_p3 @'h3000ae {
    field PptDqsCntInvTrnTg0_p3 @0 {
       bits 16;
       access rw;
       reset 16'h0;
    }
  }
  register PptDqsCntInvTrnTg1_p3 @'h3000af {
    field PptDqsCntInvTrnTg1_p3 @0 {
       bits 16;
       access rw;
       reset 16'h0;
    }
  }
  register TxDqDlyTg0_r0_p3 @'h3000c0 {
    field TxDqDlyTg0_r0_p3 @0 {
       bits 9;
       access rw;
       reset 9'h10;
    }
  }
  register TxDqDlyTg1_r0_p3 @'h3000c1 {
    field TxDqDlyTg1_r0_p3 @0 {
       bits 9;
       access rw;
       reset 9'h10;
    }
  }
  register TxDqDlyTg2_r0_p3 @'h3000c2 {
    field TxDqDlyTg2_r0_p3 @0 {
       bits 9;
       access rw;
       reset 9'h10;
    }
  }
  register TxDqDlyTg3_r0_p3 @'h3000c3 {
    field TxDqDlyTg3_r0_p3 @0 {
       bits 9;
       access rw;
       reset 9'h10;
    }
  }
  register TxDqsDlyTg0_u0_p3 @'h3000d0 {
    field TxDqsDlyTg0_u0_p3 @0 {
       bits 10;
       access rw;
       reset 10'h100;
    }
  }
  register TxDqsDlyTg1_u0_p3 @'h3000d1 {
    field TxDqsDlyTg1_u0_p3 @0 {
       bits 10;
       access rw;
       reset 10'h100;
    }
  }
  register TxDqsDlyTg2_u0_p3 @'h3000d2 {
    field TxDqsDlyTg2_u0_p3 @0 {
       bits 10;
       access rw;
       reset 10'h100;
    }
  }
  register TxDqsDlyTg3_u0_p3 @'h3000d3 {
    field TxDqsDlyTg3_u0_p3 @0 {
       bits 10;
       access rw;
       reset 10'h100;
    }
  }
  register TxImpedanceCtrl0_b1_p3 @'h300141 {
    field DrvStrenDqP @0 {
       bits 6;
       access rw;
       reset 6'h3f;
    }
    field DrvStrenDqN @6 {
       bits 6;
       access rw;
       reset 6'h3f;
    }
  }
  register DqDqsRcvCntrl_b1_p3 @'h300143 {
    field SelAnalogVref @0 {
       bits 1;
       access rw;
       reset 1'h0;
    }
    field ExtVrefRange @1 {
       bits 1;
       access rw;
       reset 1'h0;
    }
    field DfeCtrl @2 {
       bits 2;
       access rw;
       reset 2'h0;
    }
    field MajorModeDbyte @4 {
       bits 3;
       access rw;
       reset 3'h3;
    }
    field GainCurrAdj @7 {
       bits 5;
       access rw;
       reset 5'hb;
    }
    field Reserved @12 {
       bits 4;
    }
  }
  register TxImpedanceCtrl1_b1_p3 @'h300149 {
    field DrvStrenFSDqP @0 {
       bits 6;
       access rw;
       reset 6'h3f;
    }
    field DrvStrenFSDqN @6 {
       bits 6;
       access rw;
       reset 6'h3f;
    }
  }
  register TxImpedanceCtrl2_b1_p3 @'h30014b {
    field DrvStrenEQHiDqP @0 {
       bits 6;
       access rw;
       reset 6'h0;
    }
    field DrvStrenEQLoDqN @6 {
       bits 6;
       access rw;
       reset 6'h0;
    }
  }
  register TxOdtDrvStren_b1_p3 @'h30014d {
    field ODTStrenP @0 {
       bits 6;
       access rw;
       reset 6'h0;
    }
    field ODTStrenN @6 {
       bits 6;
       access rw;
       reset 6'h0;
    }
  }
  register TxSlewRate_b1_p3 @'h30015f {
    field TxPreP @0 {
       bits 4;
       access rw;
       reset 4'hf;
    }
    field TxPreN @4 {
       bits 4;
       access rw;
       reset 4'hf;
    }
    field TxPreDrvMode @8 {
       bits 3;
       access rw;
       reset 3'h7;
    }
  }
  register RxEnDlyTg0_u1_p3 @'h300180 {
    field RxEnDlyTg0_u1_p3 @0 {
       bits 11;
       access rw;
       reset 11'h100;
    }
  }
  register RxEnDlyTg1_u1_p3 @'h300181 {
    field RxEnDlyTg1_u1_p3 @0 {
       bits 11;
       access rw;
       reset 11'h100;
    }
  }
  register RxEnDlyTg2_u1_p3 @'h300182 {
    field RxEnDlyTg2_u1_p3 @0 {
       bits 11;
       access rw;
       reset 11'h100;
    }
  }
  register RxEnDlyTg3_u1_p3 @'h300183 {
    field RxEnDlyTg3_u1_p3 @0 {
       bits 11;
       access rw;
       reset 11'h100;
    }
  }
  register RxClkDlyTg0_u1_p3 @'h30018c {
    field RxClkDlyTg0_u1_p3 @0 {
       bits 6;
       access rw;
       reset 6'h10;
    }
  }
  register RxClkDlyTg1_u1_p3 @'h30018d {
    field RxClkDlyTg1_u1_p3 @0 {
       bits 6;
       access rw;
       reset 6'h10;
    }
  }
  register RxClkDlyTg2_u1_p3 @'h30018e {
    field RxClkDlyTg2_u1_p3 @0 {
       bits 6;
       access rw;
       reset 6'h10;
    }
  }
  register RxClkDlyTg3_u1_p3 @'h30018f {
    field RxClkDlyTg3_u1_p3 @0 {
       bits 6;
       access rw;
       reset 6'h10;
    }
  }
  register RxClkcDlyTg0_u1_p3 @'h300190 {
    field RxClkcDlyTg0_u1_p3 @0 {
       bits 6;
       access rw;
       reset 6'h10;
    }
  }
  register RxClkcDlyTg1_u1_p3 @'h300191 {
    field RxClkcDlyTg1_u1_p3 @0 {
       bits 6;
       access rw;
       reset 6'h10;
    }
  }
  register RxClkcDlyTg2_u1_p3 @'h300192 {
    field RxClkcDlyTg2_u1_p3 @0 {
       bits 6;
       access rw;
       reset 6'h10;
    }
  }
  register RxClkcDlyTg3_u1_p3 @'h300193 {
    field RxClkcDlyTg3_u1_p3 @0 {
       bits 6;
       access rw;
       reset 6'h10;
    }
  }
  register TxDqDlyTg0_r1_p3 @'h3001c0 {
    field TxDqDlyTg0_r1_p3 @0 {
       bits 9;
       access rw;
       reset 9'h10;
    }
  }
  register TxDqDlyTg1_r1_p3 @'h3001c1 {
    field TxDqDlyTg1_r1_p3 @0 {
       bits 9;
       access rw;
       reset 9'h10;
    }
  }
  register TxDqDlyTg2_r1_p3 @'h3001c2 {
    field TxDqDlyTg2_r1_p3 @0 {
       bits 9;
       access rw;
       reset 9'h10;
    }
  }
  register TxDqDlyTg3_r1_p3 @'h3001c3 {
    field TxDqDlyTg3_r1_p3 @0 {
       bits 9;
       access rw;
       reset 9'h10;
    }
  }
  register TxDqsDlyTg0_u1_p3 @'h3001d0 {
    field TxDqsDlyTg0_u1_p3 @0 {
       bits 10;
       access rw;
       reset 10'h100;
    }
  }
  register TxDqsDlyTg1_u1_p3 @'h3001d1 {
    field TxDqsDlyTg1_u1_p3 @0 {
       bits 10;
       access rw;
       reset 10'h100;
    }
  }
  register TxDqsDlyTg2_u1_p3 @'h3001d2 {
    field TxDqsDlyTg2_u1_p3 @0 {
       bits 10;
       access rw;
       reset 10'h100;
    }
  }
  register TxDqsDlyTg3_u1_p3 @'h3001d3 {
    field TxDqsDlyTg3_u1_p3 @0 {
       bits 10;
       access rw;
       reset 10'h100;
    }
  }
  register TxDqDlyTg0_r2_p3 @'h3002c0 {
    field TxDqDlyTg0_r2_p3 @0 {
       bits 9;
       access rw;
       reset 9'h10;
    }
  }
  register TxDqDlyTg1_r2_p3 @'h3002c1 {
    field TxDqDlyTg1_r2_p3 @0 {
       bits 9;
       access rw;
       reset 9'h10;
    }
  }
  register TxDqDlyTg2_r2_p3 @'h3002c2 {
    field TxDqDlyTg2_r2_p3 @0 {
       bits 9;
       access rw;
       reset 9'h10;
    }
  }
  register TxDqDlyTg3_r2_p3 @'h3002c3 {
    field TxDqDlyTg3_r2_p3 @0 {
       bits 9;
       access rw;
       reset 9'h10;
    }
  }
  register TxDqDlyTg0_r3_p3 @'h3003c0 {
    field TxDqDlyTg0_r3_p3 @0 {
       bits 9;
       access rw;
       reset 9'h10;
    }
  }
  register TxDqDlyTg1_r3_p3 @'h3003c1 {
    field TxDqDlyTg1_r3_p3 @0 {
       bits 9;
       access rw;
       reset 9'h10;
    }
  }
  register TxDqDlyTg2_r3_p3 @'h3003c2 {
    field TxDqDlyTg2_r3_p3 @0 {
       bits 9;
       access rw;
       reset 9'h10;
    }
  }
  register TxDqDlyTg3_r3_p3 @'h3003c3 {
    field TxDqDlyTg3_r3_p3 @0 {
       bits 9;
       access rw;
       reset 9'h10;
    }
  }
  register TxDqDlyTg0_r4_p3 @'h3004c0 {
    field TxDqDlyTg0_r4_p3 @0 {
       bits 9;
       access rw;
       reset 9'h10;
    }
  }
  register TxDqDlyTg1_r4_p3 @'h3004c1 {
    field TxDqDlyTg1_r4_p3 @0 {
       bits 9;
       access rw;
       reset 9'h10;
    }
  }
  register TxDqDlyTg2_r4_p3 @'h3004c2 {
    field TxDqDlyTg2_r4_p3 @0 {
       bits 9;
       access rw;
       reset 9'h10;
    }
  }
  register TxDqDlyTg3_r4_p3 @'h3004c3 {
    field TxDqDlyTg3_r4_p3 @0 {
       bits 9;
       access rw;
       reset 9'h10;
    }
  }
  register TxDqDlyTg0_r5_p3 @'h3005c0 {
    field TxDqDlyTg0_r5_p3 @0 {
       bits 9;
       access rw;
       reset 9'h10;
    }
  }
  register TxDqDlyTg1_r5_p3 @'h3005c1 {
    field TxDqDlyTg1_r5_p3 @0 {
       bits 9;
       access rw;
       reset 9'h10;
    }
  }
  register TxDqDlyTg2_r5_p3 @'h3005c2 {
    field TxDqDlyTg2_r5_p3 @0 {
       bits 9;
       access rw;
       reset 9'h10;
    }
  }
  register TxDqDlyTg3_r5_p3 @'h3005c3 {
    field TxDqDlyTg3_r5_p3 @0 {
       bits 9;
       access rw;
       reset 9'h10;
    }
  }
  register TxDqDlyTg0_r6_p3 @'h3006c0 {
    field TxDqDlyTg0_r6_p3 @0 {
       bits 9;
       access rw;
       reset 9'h10;
    }
  }
  register TxDqDlyTg1_r6_p3 @'h3006c1 {
    field TxDqDlyTg1_r6_p3 @0 {
       bits 9;
       access rw;
       reset 9'h10;
    }
  }
  register TxDqDlyTg2_r6_p3 @'h3006c2 {
    field TxDqDlyTg2_r6_p3 @0 {
       bits 9;
       access rw;
       reset 9'h10;
    }
  }
  register TxDqDlyTg3_r6_p3 @'h3006c3 {
    field TxDqDlyTg3_r6_p3 @0 {
       bits 9;
       access rw;
       reset 9'h10;
    }
  }
  register TxDqDlyTg0_r7_p3 @'h3007c0 {
    field TxDqDlyTg0_r7_p3 @0 {
       bits 9;
       access rw;
       reset 9'h10;
    }
  }
  register TxDqDlyTg1_r7_p3 @'h3007c1 {
    field TxDqDlyTg1_r7_p3 @0 {
       bits 9;
       access rw;
       reset 9'h10;
    }
  }
  register TxDqDlyTg2_r7_p3 @'h3007c2 {
    field TxDqDlyTg2_r7_p3 @0 {
       bits 9;
       access rw;
       reset 9'h10;
    }
  }
  register TxDqDlyTg3_r7_p3 @'h3007c3 {
    field TxDqDlyTg3_r7_p3 @0 {
       bits 9;
       access rw;
       reset 9'h10;
    }
  }
  register TxDqDlyTg0_r8_p3 @'h3008c0 {
    field TxDqDlyTg0_r8_p3 @0 {
       bits 9;
       access rw;
       reset 9'h10;
    }
  }
  register TxDqDlyTg1_r8_p3 @'h3008c1 {
    field TxDqDlyTg1_r8_p3 @0 {
       bits 9;
       access rw;
       reset 9'h10;
    }
  }
  register TxDqDlyTg2_r8_p3 @'h3008c2 {
    field TxDqDlyTg2_r8_p3 @0 {
       bits 9;
       access rw;
       reset 9'h10;
    }
  }
  register TxDqDlyTg3_r8_p3 @'h3008c3 {
    field TxDqDlyTg3_r8_p3 @0 {
       bits 9;
       access rw;
       reset 9'h10;
    }
  }
}
block dwc_ddrphy_top_DWC_DDRPHYA_DBYTE6 {
  endian little;
  bytes 2;
  register DbyteMiscMode @'h0 {
    field Reserved @0 {
       bits 2;
    }
    field DByteDisable @2 {
       bits 1;
       access rw;
       reset 1'h0;
    }
  }
  register TsmByte0 @'h1 {
    field RFU_TsmByte0 @0 {
       bits 16;
       access rw;
       reset 16'h0;
    }
  }
  register TrainingParam @'h2 {
    field RFU_TrainingParam @0 {
       bits 16;
       access rw;
       reset 16'h0;
    }
  }
  register UseDqsEnReplica_p0 @'h3 {
    field UseDqsEnReplica_p0 @0 {
       bits 1;
       access rw;
       reset 1'h0;
    }
  }
  register RxTrainPatternEnable @'h10 {
    field RxTrainPatternEnable @0 {
       bits 1;
       access rw;
       reset 1'h0;
    }
  }
  register TsmByte1 @'h11 {
    field RFU_TsmByte1 @0 {
       bits 16;
       access rw;
       reset 16'h0;
    }
  }
  register TsmByte2 @'h12 {
    field RFU_TsmByte2 @0 {
       bits 16;
       access rw;
       reset 16'h0;
    }
  }
  register TsmByte3 @'h13 {
    field RFU_TsmByte3 @0 {
       bits 9;
       access rw;
       reset 9'h0;
    }
  }
  register TsmByte4 @'h14 {
    field RFU_TsmByte4 @0 {
       bits 4;
       access rw;
       reset 4'h0;
    }
  }
  register TestModeConfig @'h17 {
    field RFU_TestModeConfig @0 {
       bits 10;
       access rw;
       reset 10'h0;
    }
  }
  register TsmByte5 @'h18 {
    field RFU_TsmByte5 @0 {
       bits 16;
       access rw;
       reset 16'h0;
    }
  }
  register MtestMuxSel @'h1a {
    field MtestMuxSel @0 {
       bits 6;
       access rw;
       reset 6'h0;
    }
  }
  register DtsmTrainModeCtrl @'h1f {
    field RFU_DtsmTrainModeCtrl @0 {
       bits 4;
       access rw;
       reset 4'h0;
    }
  }
  register DFIMRL_p0 @'h20 {
    field DFIMRL_p0 @0 {
       bits 5;
       access rw;
       reset 5'h6;
    }
  }
  register AsyncDbyteMode @'h24 {
    field AsyncDbyteMode @0 {
       bits 9;
       access rw;
       reset 9'h0;
    }
  }
  register AsyncDbyteTxEn @'h26 {
    field AsyncDbyteTxEn @0 {
       bits 12;
       access rw;
       reset 12'h0;
    }
  }
  register AsyncDbyteTxData @'h28 {
    field AsyncDbyteTxData @0 {
       bits 12;
       access rw;
       reset 12'h0;
    }
  }
  register AsyncDbyteRxData @'h2a {
    field AsyncDbyteRxData @0 {
       bits 12;
       access ro;
       reset 12'h0;
    }
  }
  register VrefDAC1_r0 @'h30 {
    field VrefDAC1_r0 @0 {
       bits 7;
       access rw;
       reset 7'h0;
    }
  }
  register TrainingCntr_r0 @'h32 {
    field RFU_TrainingCntr_r0 @0 {
       bits 16;
       access rw;
       reset 16'h0;
    }
  }
  register VrefDAC0_r0 @'h40 {
    field VrefDAC0_r0 @0 {
       bits 7;
       access rw;
       reset 7'h0;
    }
  }
  register TxImpedanceCtrl0_b0_p0 @'h41 {
    field DrvStrenDqP @0 {
       bits 6;
       access rw;
       reset 6'h3f;
    }
    field DrvStrenDqN @6 {
       bits 6;
       access rw;
       reset 6'h3f;
    }
  }
  register DqDqsRcvCntrl_b0_p0 @'h43 {
    field SelAnalogVref @0 {
       bits 1;
       access rw;
       reset 1'h0;
    }
    field ExtVrefRange @1 {
       bits 1;
       access rw;
       reset 1'h0;
    }
    field DfeCtrl @2 {
       bits 2;
       access rw;
       reset 2'h0;
    }
    field MajorModeDbyte @4 {
       bits 3;
       access rw;
       reset 3'h3;
    }
    field GainCurrAdj @7 {
       bits 5;
       access rw;
       reset 5'hb;
    }
    field Reserved @12 {
       bits 4;
    }
  }
  register TxEqualizationMode_p0 @'h48 {
    field TxEqMode @0 {
       bits 2;
       access rw;
       reset 2'h0;
    }
  }
  register TxImpedanceCtrl1_b0_p0 @'h49 {
    field DrvStrenFSDqP @0 {
       bits 6;
       access rw;
       reset 6'h3f;
    }
    field DrvStrenFSDqN @6 {
       bits 6;
       access rw;
       reset 6'h3f;
    }
  }
  register DqDqsRcvCntrl1 @'h4a {
    field PowerDownRcvr @0 {
       bits 9;
       access rw;
       reset 9'h0;
    }
    field PowerDownRcvrDqs @9 {
       bits 1;
       access rw;
       reset 1'h0;
    }
    field RxPadStandbyEn @10 {
       bits 1;
       access rw;
       reset 1'h1;
    }
    field EnLPReqPDR @11 {
       bits 1;
       access rw;
       reset 1'h0;
    }
  }
  register TxImpedanceCtrl2_b0_p0 @'h4b {
    field DrvStrenEQHiDqP @0 {
       bits 6;
       access rw;
       reset 6'h0;
    }
    field DrvStrenEQLoDqN @6 {
       bits 6;
       access rw;
       reset 6'h0;
    }
  }
  register DqDqsRcvCntrl2_p0 @'h4c {
    field EnRxAgressivePDR @0 {
       bits 1;
       access rw;
       reset 1'h0;
    }
  }
  register TxOdtDrvStren_b0_p0 @'h4d {
    field ODTStrenP @0 {
       bits 6;
       access rw;
       reset 6'h0;
    }
    field ODTStrenN @6 {
       bits 6;
       access rw;
       reset 6'h0;
    }
  }
  register RxFifoCheckStatus @'h56 {
    field RxFifoLocErr @0 {
       bits 1;
       access ro;
       reset 1'h0;
    }
    field RxFifoLocUErr @1 {
       bits 1;
       access ro;
       reset 1'h0;
    }
  }
  register RxFifoCheckErrValues @'h57 {
    field RxFifoRdLocErrValue @0 {
       bits 4;
       access ro;
       reset 4'h0;
    }
    field RxFifoWrLocErrValue @4 {
       bits 4;
       access ro;
       reset 4'h0;
    }
    field RxFifoRdLocUErrValue @8 {
       bits 4;
       access ro;
       reset 4'h0;
    }
    field RxFifoWrLocUErrValue @12 {
       bits 4;
       access ro;
       reset 4'h0;
    }
  }
  register RxFifoInfo @'h58 {
    field RxFifoRdLoc @0 {
       bits 4;
       access ro;
       reset 4'h0;
    }
    field RxFifoWrLoc @4 {
       bits 4;
       access ro;
       reset 4'h0;
    }
    field RxFifoRdLocU @8 {
       bits 4;
       access ro;
       reset 4'h0;
    }
    field RxFifoWrLocU @12 {
       bits 4;
       access ro;
       reset 4'h0;
    }
  }
  register RxFifoVisibility @'h59 {
    field RxFifoRdPtr @0 {
       bits 3;
       access rw;
       reset 3'h0;
    }
    field RxFifoRdPtrOvr @3 {
       bits 1;
       access rw;
       reset 1'h0;
    }
    field RxFifoRdEn @4 {
       bits 1;
       access rw;
       reset 1'h0;
    }
  }
  register RxFifoContentsDQ3210 @'h5a {
    field RxFifoContentsDQ3210 @0 {
       bits 16;
       access ro;
       reset 16'h0;
    }
  }
  register RxFifoContentsDQ7654 @'h5b {
    field RxFifoContentsDQ7654 @0 {
       bits 16;
       access ro;
       reset 16'h0;
    }
  }
  register RxFifoContentsDBI @'h5c {
    field RxFifoContentsDBI @0 {
       bits 4;
       access ro;
       reset 4'h0;
    }
  }
  register TxSlewRate_b0_p0 @'h5f {
    field TxPreP @0 {
       bits 4;
       access rw;
       reset 4'hf;
    }
    field TxPreN @4 {
       bits 4;
       access rw;
       reset 4'hf;
    }
    field TxPreDrvMode @8 {
       bits 3;
       access rw;
       reset 3'h7;
    }
  }
  register TrainingIncDecDtsmEn_r0 @'h62 {
    field TrainingIncDecDtsmEn_r0 @0 {
       bits 9;
       access rw;
       reset 9'h0;
    }
  }
  register RxPBDlyTg0_r0 @'h68 {
    field RxPBDlyTg0_r0 @0 {
       bits 7;
       access rw;
       reset 7'h0;
    }
  }
  register RxPBDlyTg1_r0 @'h69 {
    field RxPBDlyTg1_r0 @0 {
       bits 7;
       access rw;
       reset 7'h0;
    }
  }
  register RxPBDlyTg2_r0 @'h6a {
    field RxPBDlyTg2_r0 @0 {
       bits 7;
       access rw;
       reset 7'h0;
    }
  }
  register RxPBDlyTg3_r0 @'h6b {
    field RxPBDlyTg3_r0 @0 {
       bits 7;
       access rw;
       reset 7'h0;
    }
  }
  register RxEnDlyTg0_u0_p0 @'h80 {
    field RxEnDlyTg0_u0_p0 @0 {
       bits 11;
       access rw;
       reset 11'h100;
    }
  }
  register RxEnDlyTg1_u0_p0 @'h81 {
    field RxEnDlyTg1_u0_p0 @0 {
       bits 11;
       access rw;
       reset 11'h100;
    }
  }
  register RxEnDlyTg2_u0_p0 @'h82 {
    field RxEnDlyTg2_u0_p0 @0 {
       bits 11;
       access rw;
       reset 11'h100;
    }
  }
  register RxEnDlyTg3_u0_p0 @'h83 {
    field RxEnDlyTg3_u0_p0 @0 {
       bits 11;
       access rw;
       reset 11'h100;
    }
  }
  register RxClkDlyTg0_u0_p0 @'h8c {
    field RxClkDlyTg0_u0_p0 @0 {
       bits 6;
       access rw;
       reset 6'h10;
    }
  }
  register RxClkDlyTg1_u0_p0 @'h8d {
    field RxClkDlyTg1_u0_p0 @0 {
       bits 6;
       access rw;
       reset 6'h10;
    }
  }
  register RxClkDlyTg2_u0_p0 @'h8e {
    field RxClkDlyTg2_u0_p0 @0 {
       bits 6;
       access rw;
       reset 6'h10;
    }
  }
  register RxClkDlyTg3_u0_p0 @'h8f {
    field RxClkDlyTg3_u0_p0 @0 {
       bits 6;
       access rw;
       reset 6'h10;
    }
  }
  register RxClkcDlyTg0_u0_p0 @'h90 {
    field RxClkcDlyTg0_u0_p0 @0 {
       bits 6;
       access rw;
       reset 6'h10;
    }
  }
  register RxClkcDlyTg1_u0_p0 @'h91 {
    field RxClkcDlyTg1_u0_p0 @0 {
       bits 6;
       access rw;
       reset 6'h10;
    }
  }
  register RxClkcDlyTg2_u0_p0 @'h92 {
    field RxClkcDlyTg2_u0_p0 @0 {
       bits 6;
       access rw;
       reset 6'h10;
    }
  }
  register RxClkcDlyTg3_u0_p0 @'h93 {
    field RxClkcDlyTg3_u0_p0 @0 {
       bits 6;
       access rw;
       reset 6'h10;
    }
  }
  register Dq0LnSel @'ha0 {
    field Dq0LnSel @0 {
       bits 3;
       access rw;
       reset 3'h0;
    }
  }
  register Dq1LnSel @'ha1 {
    field Dq1LnSel @0 {
       bits 3;
       access rw;
       reset 3'h1;
    }
  }
  register Dq2LnSel @'ha2 {
    field Dq2LnSel @0 {
       bits 3;
       access rw;
       reset 3'h2;
    }
  }
  register Dq3LnSel @'ha3 {
    field Dq3LnSel @0 {
       bits 3;
       access rw;
       reset 3'h3;
    }
  }
  register Dq4LnSel @'ha4 {
    field Dq4LnSel @0 {
       bits 3;
       access rw;
       reset 3'h4;
    }
  }
  register Dq5LnSel @'ha5 {
    field Dq5LnSel @0 {
       bits 3;
       access rw;
       reset 3'h5;
    }
  }
  register Dq6LnSel @'ha6 {
    field Dq6LnSel @0 {
       bits 3;
       access rw;
       reset 3'h6;
    }
  }
  register Dq7LnSel @'ha7 {
    field Dq7LnSel @0 {
       bits 3;
       access rw;
       reset 3'h7;
    }
  }
  register PptCtlStatic @'haa {
    field RFU_PptCtlStatic @0 {
       bits 12;
       access rw;
       reset 12'h0;
    }
  }
  register PptCtlDyn @'hab {
    field RFU_PptCtlDyn @0 {
       bits 2;
       access rw;
       reset 2'h0;
    }
  }
  register PptInfo @'hac {
    field PptInfo @0 {
       bits 16;
       access ro;
       reset 16'h0;
    }
  }
  register PptRxEnEvnt @'had {
    field RFU_PptRxEnEvnt @0 {
       bits 2;
       access rw;
       reset 2'h0;
    }
  }
  register PptDqsCntInvTrnTg0_p0 @'hae {
    field PptDqsCntInvTrnTg0_p0 @0 {
       bits 16;
       access rw;
       reset 16'h0;
    }
  }
  register PptDqsCntInvTrnTg1_p0 @'haf {
    field PptDqsCntInvTrnTg1_p0 @0 {
       bits 16;
       access rw;
       reset 16'h0;
    }
  }
  register DtsmBlankingCtrl @'hb1 {
    field RFU_DtsmBlankingCtrl @0 {
       bits 10;
       access rw;
       reset 10'h0;
    }
  }
  register Tsm0_i0 @'hb2 {
    field RFU_Tsm0_i0 @0 {
       bits 14;
       access rw;
       reset 14'h0;
    }
  }
  register Tsm1_i0 @'hb3 {
    field RFU_Tsm1_i0 @0 {
       bits 16;
       access ro;
       reset 16'h0;
    }
  }
  register Tsm2_i0 @'hb4 {
    field RFU_Tsm2_i0 @0 {
       bits 1;
       access rw;
       reset 1'h0;
    }
  }
  register Tsm3 @'hb5 {
    field RFU_Tsm3 @0 {
       bits 10;
       access rw;
       reset 10'h0;
    }
  }
  register TxChkDataSelects @'hb6 {
    field RFU_TxChkDataSelects @0 {
       bits 2;
       access rw;
       reset 2'h0;
    }
  }
  register DtsmUpThldXingInd @'hb7 {
    field DtsmUpThldXingInd @0 {
       bits 9;
       access ro;
       reset 9'h0;
    }
  }
  register DtsmLoThldXingInd @'hb8 {
    field DtsmLoThldXingInd @0 {
       bits 9;
       access ro;
       reset 9'h0;
    }
  }
  register DbyteAllDtsmCtrl0 @'hb9 {
    field RFU_DbyteAllDtsmCtrl0 @0 {
       bits 9;
       access rw;
       reset 9'h0;
    }
  }
  register DbyteAllDtsmCtrl1 @'hba {
    field RFU_DbyteAllDtsmCtrl1 @0 {
       bits 9;
       access rw;
       reset 9'h0;
    }
  }
  register DbyteAllDtsmCtrl2 @'hbb {
    field RFU_DbyteAllDtsmCtrl2 @0 {
       bits 9;
       access rw;
       reset 9'h0;
    }
  }
  register TxDqDlyTg0_r0_p0 @'hc0 {
    field TxDqDlyTg0_r0_p0 @0 {
       bits 9;
       access rw;
       reset 9'h10;
    }
  }
  register TxDqDlyTg1_r0_p0 @'hc1 {
    field TxDqDlyTg1_r0_p0 @0 {
       bits 9;
       access rw;
       reset 9'h10;
    }
  }
  register TxDqDlyTg2_r0_p0 @'hc2 {
    field TxDqDlyTg2_r0_p0 @0 {
       bits 9;
       access rw;
       reset 9'h10;
    }
  }
  register TxDqDlyTg3_r0_p0 @'hc3 {
    field TxDqDlyTg3_r0_p0 @0 {
       bits 9;
       access rw;
       reset 9'h10;
    }
  }
  register TxDqsDlyTg0_u0_p0 @'hd0 {
    field TxDqsDlyTg0_u0_p0 @0 {
       bits 10;
       access rw;
       reset 10'h100;
    }
  }
  register TxDqsDlyTg1_u0_p0 @'hd1 {
    field TxDqsDlyTg1_u0_p0 @0 {
       bits 10;
       access rw;
       reset 10'h100;
    }
  }
  register TxDqsDlyTg2_u0_p0 @'hd2 {
    field TxDqsDlyTg2_u0_p0 @0 {
       bits 10;
       access rw;
       reset 10'h100;
    }
  }
  register TxDqsDlyTg3_u0_p0 @'hd3 {
    field TxDqsDlyTg3_u0_p0 @0 {
       bits 10;
       access rw;
       reset 10'h100;
    }
  }
  register DxLcdlStatus @'he4 {
    field DxLcdlFineSnapVal @0 {
       bits 10;
       access ro;
       reset 10'h0;
    }
    field DxLcdlPhdSnapVal @10 {
       bits 1;
       access ro;
       reset 1'h0;
    }
    field DxLcdlStickyLock @11 {
       bits 1;
       access ro;
       reset 1'h0;
    }
    field DxLcdlStickyUnlock @12 {
       bits 1;
       access ro;
       reset 1'h0;
    }
    field DxLcdlLiveLock @13 {
       bits 1;
       access ro;
       reset 1'h0;
    }
  }
  register VrefDAC1_r1 @'h130 {
    field VrefDAC1_r1 @0 {
       bits 7;
       access rw;
       reset 7'h0;
    }
  }
  register TrainingCntr_r1 @'h132 {
    field RFU_TrainingCntr_r1 @0 {
       bits 16;
       access rw;
       reset 16'h0;
    }
  }
  register VrefDAC0_r1 @'h140 {
    field VrefDAC0_r1 @0 {
       bits 7;
       access rw;
       reset 7'h0;
    }
  }
  register TxImpedanceCtrl0_b1_p0 @'h141 {
    field DrvStrenDqP @0 {
       bits 6;
       access rw;
       reset 6'h3f;
    }
    field DrvStrenDqN @6 {
       bits 6;
       access rw;
       reset 6'h3f;
    }
  }
  register DqDqsRcvCntrl_b1_p0 @'h143 {
    field SelAnalogVref @0 {
       bits 1;
       access rw;
       reset 1'h0;
    }
    field ExtVrefRange @1 {
       bits 1;
       access rw;
       reset 1'h0;
    }
    field DfeCtrl @2 {
       bits 2;
       access rw;
       reset 2'h0;
    }
    field MajorModeDbyte @4 {
       bits 3;
       access rw;
       reset 3'h3;
    }
    field GainCurrAdj @7 {
       bits 5;
       access rw;
       reset 5'hb;
    }
    field Reserved @12 {
       bits 4;
    }
  }
  register TxImpedanceCtrl1_b1_p0 @'h149 {
    field DrvStrenFSDqP @0 {
       bits 6;
       access rw;
       reset 6'h3f;
    }
    field DrvStrenFSDqN @6 {
       bits 6;
       access rw;
       reset 6'h3f;
    }
  }
  register TxImpedanceCtrl2_b1_p0 @'h14b {
    field DrvStrenEQHiDqP @0 {
       bits 6;
       access rw;
       reset 6'h0;
    }
    field DrvStrenEQLoDqN @6 {
       bits 6;
       access rw;
       reset 6'h0;
    }
  }
  register TxOdtDrvStren_b1_p0 @'h14d {
    field ODTStrenP @0 {
       bits 6;
       access rw;
       reset 6'h0;
    }
    field ODTStrenN @6 {
       bits 6;
       access rw;
       reset 6'h0;
    }
  }
  register TxSlewRate_b1_p0 @'h15f {
    field TxPreP @0 {
       bits 4;
       access rw;
       reset 4'hf;
    }
    field TxPreN @4 {
       bits 4;
       access rw;
       reset 4'hf;
    }
    field TxPreDrvMode @8 {
       bits 3;
       access rw;
       reset 3'h7;
    }
  }
  register TrainingIncDecDtsmEn_r1 @'h162 {
    field TrainingIncDecDtsmEn_r1 @0 {
       bits 9;
       access rw;
       reset 9'h0;
    }
  }
  register RxPBDlyTg0_r1 @'h168 {
    field RxPBDlyTg0_r1 @0 {
       bits 7;
       access rw;
       reset 7'h0;
    }
  }
  register RxPBDlyTg1_r1 @'h169 {
    field RxPBDlyTg1_r1 @0 {
       bits 7;
       access rw;
       reset 7'h0;
    }
  }
  register RxPBDlyTg2_r1 @'h16a {
    field RxPBDlyTg2_r1 @0 {
       bits 7;
       access rw;
       reset 7'h0;
    }
  }
  register RxPBDlyTg3_r1 @'h16b {
    field RxPBDlyTg3_r1 @0 {
       bits 7;
       access rw;
       reset 7'h0;
    }
  }
  register RxEnDlyTg0_u1_p0 @'h180 {
    field RxEnDlyTg0_u1_p0 @0 {
       bits 11;
       access rw;
       reset 11'h100;
    }
  }
  register RxEnDlyTg1_u1_p0 @'h181 {
    field RxEnDlyTg1_u1_p0 @0 {
       bits 11;
       access rw;
       reset 11'h100;
    }
  }
  register RxEnDlyTg2_u1_p0 @'h182 {
    field RxEnDlyTg2_u1_p0 @0 {
       bits 11;
       access rw;
       reset 11'h100;
    }
  }
  register RxEnDlyTg3_u1_p0 @'h183 {
    field RxEnDlyTg3_u1_p0 @0 {
       bits 11;
       access rw;
       reset 11'h100;
    }
  }
  register RxClkDlyTg0_u1_p0 @'h18c {
    field RxClkDlyTg0_u1_p0 @0 {
       bits 6;
       access rw;
       reset 6'h10;
    }
  }
  register RxClkDlyTg1_u1_p0 @'h18d {
    field RxClkDlyTg1_u1_p0 @0 {
       bits 6;
       access rw;
       reset 6'h10;
    }
  }
  register RxClkDlyTg2_u1_p0 @'h18e {
    field RxClkDlyTg2_u1_p0 @0 {
       bits 6;
       access rw;
       reset 6'h10;
    }
  }
  register RxClkDlyTg3_u1_p0 @'h18f {
    field RxClkDlyTg3_u1_p0 @0 {
       bits 6;
       access rw;
       reset 6'h10;
    }
  }
  register RxClkcDlyTg0_u1_p0 @'h190 {
    field RxClkcDlyTg0_u1_p0 @0 {
       bits 6;
       access rw;
       reset 6'h10;
    }
  }
  register RxClkcDlyTg1_u1_p0 @'h191 {
    field RxClkcDlyTg1_u1_p0 @0 {
       bits 6;
       access rw;
       reset 6'h10;
    }
  }
  register RxClkcDlyTg2_u1_p0 @'h192 {
    field RxClkcDlyTg2_u1_p0 @0 {
       bits 6;
       access rw;
       reset 6'h10;
    }
  }
  register RxClkcDlyTg3_u1_p0 @'h193 {
    field RxClkcDlyTg3_u1_p0 @0 {
       bits 6;
       access rw;
       reset 6'h10;
    }
  }
  register Tsm0_i1 @'h1b2 {
    field RFU_Tsm0_i1 @0 {
       bits 14;
       access rw;
       reset 14'h0;
    }
  }
  register Tsm1_i1 @'h1b3 {
    field RFU_Tsm1_i1 @0 {
       bits 16;
       access ro;
       reset 16'h0;
    }
  }
  register Tsm2_i1 @'h1b4 {
    field RFU_Tsm2_i1 @0 {
       bits 1;
       access rw;
       reset 1'h0;
    }
  }
  register TxDqDlyTg0_r1_p0 @'h1c0 {
    field TxDqDlyTg0_r1_p0 @0 {
       bits 9;
       access rw;
       reset 9'h10;
    }
  }
  register TxDqDlyTg1_r1_p0 @'h1c1 {
    field TxDqDlyTg1_r1_p0 @0 {
       bits 9;
       access rw;
       reset 9'h10;
    }
  }
  register TxDqDlyTg2_r1_p0 @'h1c2 {
    field TxDqDlyTg2_r1_p0 @0 {
       bits 9;
       access rw;
       reset 9'h10;
    }
  }
  register TxDqDlyTg3_r1_p0 @'h1c3 {
    field TxDqDlyTg3_r1_p0 @0 {
       bits 9;
       access rw;
       reset 9'h10;
    }
  }
  register TxDqsDlyTg0_u1_p0 @'h1d0 {
    field TxDqsDlyTg0_u1_p0 @0 {
       bits 10;
       access rw;
       reset 10'h100;
    }
  }
  register TxDqsDlyTg1_u1_p0 @'h1d1 {
    field TxDqsDlyTg1_u1_p0 @0 {
       bits 10;
       access rw;
       reset 10'h100;
    }
  }
  register TxDqsDlyTg2_u1_p0 @'h1d2 {
    field TxDqsDlyTg2_u1_p0 @0 {
       bits 10;
       access rw;
       reset 10'h100;
    }
  }
  register TxDqsDlyTg3_u1_p0 @'h1d3 {
    field TxDqsDlyTg3_u1_p0 @0 {
       bits 10;
       access rw;
       reset 10'h100;
    }
  }
  register VrefDAC1_r2 @'h230 {
    field VrefDAC1_r2 @0 {
       bits 7;
       access rw;
       reset 7'h0;
    }
  }
  register TrainingCntr_r2 @'h232 {
    field RFU_TrainingCntr_r2 @0 {
       bits 16;
       access rw;
       reset 16'h0;
    }
  }
  register VrefDAC0_r2 @'h240 {
    field VrefDAC0_r2 @0 {
       bits 7;
       access rw;
       reset 7'h0;
    }
  }
  register TrainingIncDecDtsmEn_r2 @'h262 {
    field TrainingIncDecDtsmEn_r2 @0 {
       bits 9;
       access rw;
       reset 9'h0;
    }
  }
  register RxPBDlyTg0_r2 @'h268 {
    field RxPBDlyTg0_r2 @0 {
       bits 7;
       access rw;
       reset 7'h0;
    }
  }
  register RxPBDlyTg1_r2 @'h269 {
    field RxPBDlyTg1_r2 @0 {
       bits 7;
       access rw;
       reset 7'h0;
    }
  }
  register RxPBDlyTg2_r2 @'h26a {
    field RxPBDlyTg2_r2 @0 {
       bits 7;
       access rw;
       reset 7'h0;
    }
  }
  register RxPBDlyTg3_r2 @'h26b {
    field RxPBDlyTg3_r2 @0 {
       bits 7;
       access rw;
       reset 7'h0;
    }
  }
  register Tsm0_i2 @'h2b2 {
    field RFU_Tsm0_i2 @0 {
       bits 14;
       access rw;
       reset 14'h0;
    }
  }
  register Tsm1_i2 @'h2b3 {
    field RFU_Tsm1_i2 @0 {
       bits 16;
       access ro;
       reset 16'h0;
    }
  }
  register Tsm2_i2 @'h2b4 {
    field RFU_Tsm2_i2 @0 {
       bits 1;
       access rw;
       reset 1'h0;
    }
  }
  register TxDqDlyTg0_r2_p0 @'h2c0 {
    field TxDqDlyTg0_r2_p0 @0 {
       bits 9;
       access rw;
       reset 9'h10;
    }
  }
  register TxDqDlyTg1_r2_p0 @'h2c1 {
    field TxDqDlyTg1_r2_p0 @0 {
       bits 9;
       access rw;
       reset 9'h10;
    }
  }
  register TxDqDlyTg2_r2_p0 @'h2c2 {
    field TxDqDlyTg2_r2_p0 @0 {
       bits 9;
       access rw;
       reset 9'h10;
    }
  }
  register TxDqDlyTg3_r2_p0 @'h2c3 {
    field TxDqDlyTg3_r2_p0 @0 {
       bits 9;
       access rw;
       reset 9'h10;
    }
  }
  register VrefDAC1_r3 @'h330 {
    field VrefDAC1_r3 @0 {
       bits 7;
       access rw;
       reset 7'h0;
    }
  }
  register TrainingCntr_r3 @'h332 {
    field RFU_TrainingCntr_r3 @0 {
       bits 16;
       access rw;
       reset 16'h0;
    }
  }
  register VrefDAC0_r3 @'h340 {
    field VrefDAC0_r3 @0 {
       bits 7;
       access rw;
       reset 7'h0;
    }
  }
  register TrainingIncDecDtsmEn_r3 @'h362 {
    field TrainingIncDecDtsmEn_r3 @0 {
       bits 9;
       access rw;
       reset 9'h0;
    }
  }
  register RxPBDlyTg0_r3 @'h368 {
    field RxPBDlyTg0_r3 @0 {
       bits 7;
       access rw;
       reset 7'h0;
    }
  }
  register RxPBDlyTg1_r3 @'h369 {
    field RxPBDlyTg1_r3 @0 {
       bits 7;
       access rw;
       reset 7'h0;
    }
  }
  register RxPBDlyTg2_r3 @'h36a {
    field RxPBDlyTg2_r3 @0 {
       bits 7;
       access rw;
       reset 7'h0;
    }
  }
  register RxPBDlyTg3_r3 @'h36b {
    field RxPBDlyTg3_r3 @0 {
       bits 7;
       access rw;
       reset 7'h0;
    }
  }
  register Tsm0_i3 @'h3b2 {
    field RFU_Tsm0_i3 @0 {
       bits 14;
       access rw;
       reset 14'h0;
    }
  }
  register Tsm1_i3 @'h3b3 {
    field RFU_Tsm1_i3 @0 {
       bits 16;
       access ro;
       reset 16'h0;
    }
  }
  register Tsm2_i3 @'h3b4 {
    field RFU_Tsm2_i3 @0 {
       bits 1;
       access rw;
       reset 1'h0;
    }
  }
  register TxDqDlyTg0_r3_p0 @'h3c0 {
    field TxDqDlyTg0_r3_p0 @0 {
       bits 9;
       access rw;
       reset 9'h10;
    }
  }
  register TxDqDlyTg1_r3_p0 @'h3c1 {
    field TxDqDlyTg1_r3_p0 @0 {
       bits 9;
       access rw;
       reset 9'h10;
    }
  }
  register TxDqDlyTg2_r3_p0 @'h3c2 {
    field TxDqDlyTg2_r3_p0 @0 {
       bits 9;
       access rw;
       reset 9'h10;
    }
  }
  register TxDqDlyTg3_r3_p0 @'h3c3 {
    field TxDqDlyTg3_r3_p0 @0 {
       bits 9;
       access rw;
       reset 9'h10;
    }
  }
  register VrefDAC1_r4 @'h430 {
    field VrefDAC1_r4 @0 {
       bits 7;
       access rw;
       reset 7'h0;
    }
  }
  register TrainingCntr_r4 @'h432 {
    field RFU_TrainingCntr_r4 @0 {
       bits 16;
       access rw;
       reset 16'h0;
    }
  }
  register VrefDAC0_r4 @'h440 {
    field VrefDAC0_r4 @0 {
       bits 7;
       access rw;
       reset 7'h0;
    }
  }
  register TrainingIncDecDtsmEn_r4 @'h462 {
    field TrainingIncDecDtsmEn_r4 @0 {
       bits 9;
       access rw;
       reset 9'h0;
    }
  }
  register RxPBDlyTg0_r4 @'h468 {
    field RxPBDlyTg0_r4 @0 {
       bits 7;
       access rw;
       reset 7'h0;
    }
  }
  register RxPBDlyTg1_r4 @'h469 {
    field RxPBDlyTg1_r4 @0 {
       bits 7;
       access rw;
       reset 7'h0;
    }
  }
  register RxPBDlyTg2_r4 @'h46a {
    field RxPBDlyTg2_r4 @0 {
       bits 7;
       access rw;
       reset 7'h0;
    }
  }
  register RxPBDlyTg3_r4 @'h46b {
    field RxPBDlyTg3_r4 @0 {
       bits 7;
       access rw;
       reset 7'h0;
    }
  }
  register Tsm0_i4 @'h4b2 {
    field RFU_Tsm0_i4 @0 {
       bits 14;
       access rw;
       reset 14'h0;
    }
  }
  register Tsm1_i4 @'h4b3 {
    field RFU_Tsm1_i4 @0 {
       bits 16;
       access ro;
       reset 16'h0;
    }
  }
  register Tsm2_i4 @'h4b4 {
    field RFU_Tsm2_i4 @0 {
       bits 1;
       access rw;
       reset 1'h0;
    }
  }
  register TxDqDlyTg0_r4_p0 @'h4c0 {
    field TxDqDlyTg0_r4_p0 @0 {
       bits 9;
       access rw;
       reset 9'h10;
    }
  }
  register TxDqDlyTg1_r4_p0 @'h4c1 {
    field TxDqDlyTg1_r4_p0 @0 {
       bits 9;
       access rw;
       reset 9'h10;
    }
  }
  register TxDqDlyTg2_r4_p0 @'h4c2 {
    field TxDqDlyTg2_r4_p0 @0 {
       bits 9;
       access rw;
       reset 9'h10;
    }
  }
  register TxDqDlyTg3_r4_p0 @'h4c3 {
    field TxDqDlyTg3_r4_p0 @0 {
       bits 9;
       access rw;
       reset 9'h10;
    }
  }
  register VrefDAC1_r5 @'h530 {
    field VrefDAC1_r5 @0 {
       bits 7;
       access rw;
       reset 7'h0;
    }
  }
  register TrainingCntr_r5 @'h532 {
    field RFU_TrainingCntr_r5 @0 {
       bits 16;
       access rw;
       reset 16'h0;
    }
  }
  register VrefDAC0_r5 @'h540 {
    field VrefDAC0_r5 @0 {
       bits 7;
       access rw;
       reset 7'h0;
    }
  }
  register TrainingIncDecDtsmEn_r5 @'h562 {
    field TrainingIncDecDtsmEn_r5 @0 {
       bits 9;
       access rw;
       reset 9'h0;
    }
  }
  register RxPBDlyTg0_r5 @'h568 {
    field RxPBDlyTg0_r5 @0 {
       bits 7;
       access rw;
       reset 7'h0;
    }
  }
  register RxPBDlyTg1_r5 @'h569 {
    field RxPBDlyTg1_r5 @0 {
       bits 7;
       access rw;
       reset 7'h0;
    }
  }
  register RxPBDlyTg2_r5 @'h56a {
    field RxPBDlyTg2_r5 @0 {
       bits 7;
       access rw;
       reset 7'h0;
    }
  }
  register RxPBDlyTg3_r5 @'h56b {
    field RxPBDlyTg3_r5 @0 {
       bits 7;
       access rw;
       reset 7'h0;
    }
  }
  register Tsm0_i5 @'h5b2 {
    field RFU_Tsm0_i5 @0 {
       bits 14;
       access rw;
       reset 14'h0;
    }
  }
  register Tsm1_i5 @'h5b3 {
    field RFU_Tsm1_i5 @0 {
       bits 16;
       access ro;
       reset 16'h0;
    }
  }
  register Tsm2_i5 @'h5b4 {
    field RFU_Tsm2_i5 @0 {
       bits 1;
       access rw;
       reset 1'h0;
    }
  }
  register TxDqDlyTg0_r5_p0 @'h5c0 {
    field TxDqDlyTg0_r5_p0 @0 {
       bits 9;
       access rw;
       reset 9'h10;
    }
  }
  register TxDqDlyTg1_r5_p0 @'h5c1 {
    field TxDqDlyTg1_r5_p0 @0 {
       bits 9;
       access rw;
       reset 9'h10;
    }
  }
  register TxDqDlyTg2_r5_p0 @'h5c2 {
    field TxDqDlyTg2_r5_p0 @0 {
       bits 9;
       access rw;
       reset 9'h10;
    }
  }
  register TxDqDlyTg3_r5_p0 @'h5c3 {
    field TxDqDlyTg3_r5_p0 @0 {
       bits 9;
       access rw;
       reset 9'h10;
    }
  }
  register VrefDAC1_r6 @'h630 {
    field VrefDAC1_r6 @0 {
       bits 7;
       access rw;
       reset 7'h0;
    }
  }
  register TrainingCntr_r6 @'h632 {
    field RFU_TrainingCntr_r6 @0 {
       bits 16;
       access rw;
       reset 16'h0;
    }
  }
  register VrefDAC0_r6 @'h640 {
    field VrefDAC0_r6 @0 {
       bits 7;
       access rw;
       reset 7'h0;
    }
  }
  register TrainingIncDecDtsmEn_r6 @'h662 {
    field TrainingIncDecDtsmEn_r6 @0 {
       bits 9;
       access rw;
       reset 9'h0;
    }
  }
  register RxPBDlyTg0_r6 @'h668 {
    field RxPBDlyTg0_r6 @0 {
       bits 7;
       access rw;
       reset 7'h0;
    }
  }
  register RxPBDlyTg1_r6 @'h669 {
    field RxPBDlyTg1_r6 @0 {
       bits 7;
       access rw;
       reset 7'h0;
    }
  }
  register RxPBDlyTg2_r6 @'h66a {
    field RxPBDlyTg2_r6 @0 {
       bits 7;
       access rw;
       reset 7'h0;
    }
  }
  register RxPBDlyTg3_r6 @'h66b {
    field RxPBDlyTg3_r6 @0 {
       bits 7;
       access rw;
       reset 7'h0;
    }
  }
  register Tsm0_i6 @'h6b2 {
    field RFU_Tsm0_i6 @0 {
       bits 14;
       access rw;
       reset 14'h0;
    }
  }
  register Tsm1_i6 @'h6b3 {
    field RFU_Tsm1_i6 @0 {
       bits 16;
       access ro;
       reset 16'h0;
    }
  }
  register Tsm2_i6 @'h6b4 {
    field RFU_Tsm2_i6 @0 {
       bits 1;
       access rw;
       reset 1'h0;
    }
  }
  register TxDqDlyTg0_r6_p0 @'h6c0 {
    field TxDqDlyTg0_r6_p0 @0 {
       bits 9;
       access rw;
       reset 9'h10;
    }
  }
  register TxDqDlyTg1_r6_p0 @'h6c1 {
    field TxDqDlyTg1_r6_p0 @0 {
       bits 9;
       access rw;
       reset 9'h10;
    }
  }
  register TxDqDlyTg2_r6_p0 @'h6c2 {
    field TxDqDlyTg2_r6_p0 @0 {
       bits 9;
       access rw;
       reset 9'h10;
    }
  }
  register TxDqDlyTg3_r6_p0 @'h6c3 {
    field TxDqDlyTg3_r6_p0 @0 {
       bits 9;
       access rw;
       reset 9'h10;
    }
  }
  register VrefDAC1_r7 @'h730 {
    field VrefDAC1_r7 @0 {
       bits 7;
       access rw;
       reset 7'h0;
    }
  }
  register TrainingCntr_r7 @'h732 {
    field RFU_TrainingCntr_r7 @0 {
       bits 16;
       access rw;
       reset 16'h0;
    }
  }
  register VrefDAC0_r7 @'h740 {
    field VrefDAC0_r7 @0 {
       bits 7;
       access rw;
       reset 7'h0;
    }
  }
  register TrainingIncDecDtsmEn_r7 @'h762 {
    field TrainingIncDecDtsmEn_r7 @0 {
       bits 9;
       access rw;
       reset 9'h0;
    }
  }
  register RxPBDlyTg0_r7 @'h768 {
    field RxPBDlyTg0_r7 @0 {
       bits 7;
       access rw;
       reset 7'h0;
    }
  }
  register RxPBDlyTg1_r7 @'h769 {
    field RxPBDlyTg1_r7 @0 {
       bits 7;
       access rw;
       reset 7'h0;
    }
  }
  register RxPBDlyTg2_r7 @'h76a {
    field RxPBDlyTg2_r7 @0 {
       bits 7;
       access rw;
       reset 7'h0;
    }
  }
  register RxPBDlyTg3_r7 @'h76b {
    field RxPBDlyTg3_r7 @0 {
       bits 7;
       access rw;
       reset 7'h0;
    }
  }
  register Tsm0_i7 @'h7b2 {
    field RFU_Tsm0_i7 @0 {
       bits 14;
       access rw;
       reset 14'h0;
    }
  }
  register Tsm1_i7 @'h7b3 {
    field RFU_Tsm1_i7 @0 {
       bits 16;
       access ro;
       reset 16'h0;
    }
  }
  register Tsm2_i7 @'h7b4 {
    field RFU_Tsm2_i7 @0 {
       bits 1;
       access rw;
       reset 1'h0;
    }
  }
  register TxDqDlyTg0_r7_p0 @'h7c0 {
    field TxDqDlyTg0_r7_p0 @0 {
       bits 9;
       access rw;
       reset 9'h10;
    }
  }
  register TxDqDlyTg1_r7_p0 @'h7c1 {
    field TxDqDlyTg1_r7_p0 @0 {
       bits 9;
       access rw;
       reset 9'h10;
    }
  }
  register TxDqDlyTg2_r7_p0 @'h7c2 {
    field TxDqDlyTg2_r7_p0 @0 {
       bits 9;
       access rw;
       reset 9'h10;
    }
  }
  register TxDqDlyTg3_r7_p0 @'h7c3 {
    field TxDqDlyTg3_r7_p0 @0 {
       bits 9;
       access rw;
       reset 9'h10;
    }
  }
  register VrefDAC1_r8 @'h830 {
    field VrefDAC1_r8 @0 {
       bits 7;
       access rw;
       reset 7'h0;
    }
  }
  register TrainingCntr_r8 @'h832 {
    field RFU_TrainingCntr_r8 @0 {
       bits 16;
       access rw;
       reset 16'h0;
    }
  }
  register VrefDAC0_r8 @'h840 {
    field VrefDAC0_r8 @0 {
       bits 7;
       access rw;
       reset 7'h0;
    }
  }
  register TrainingIncDecDtsmEn_r8 @'h862 {
    field TrainingIncDecDtsmEn_r8 @0 {
       bits 9;
       access rw;
       reset 9'h0;
    }
  }
  register RxPBDlyTg0_r8 @'h868 {
    field RxPBDlyTg0_r8 @0 {
       bits 7;
       access rw;
       reset 7'h0;
    }
  }
  register RxPBDlyTg1_r8 @'h869 {
    field RxPBDlyTg1_r8 @0 {
       bits 7;
       access rw;
       reset 7'h0;
    }
  }
  register RxPBDlyTg2_r8 @'h86a {
    field RxPBDlyTg2_r8 @0 {
       bits 7;
       access rw;
       reset 7'h0;
    }
  }
  register RxPBDlyTg3_r8 @'h86b {
    field RxPBDlyTg3_r8 @0 {
       bits 7;
       access rw;
       reset 7'h0;
    }
  }
  register Tsm0_i8 @'h8b2 {
    field RFU_Tsm0_i8 @0 {
       bits 14;
       access rw;
       reset 14'h0;
    }
  }
  register Tsm1_i8 @'h8b3 {
    field RFU_Tsm1_i8 @0 {
       bits 16;
       access ro;
       reset 16'h0;
    }
  }
  register Tsm2_i8 @'h8b4 {
    field RFU_Tsm2_i8 @0 {
       bits 1;
       access rw;
       reset 1'h0;
    }
  }
  register TxDqDlyTg0_r8_p0 @'h8c0 {
    field TxDqDlyTg0_r8_p0 @0 {
       bits 9;
       access rw;
       reset 9'h10;
    }
  }
  register TxDqDlyTg1_r8_p0 @'h8c1 {
    field TxDqDlyTg1_r8_p0 @0 {
       bits 9;
       access rw;
       reset 9'h10;
    }
  }
  register TxDqDlyTg2_r8_p0 @'h8c2 {
    field TxDqDlyTg2_r8_p0 @0 {
       bits 9;
       access rw;
       reset 9'h10;
    }
  }
  register TxDqDlyTg3_r8_p0 @'h8c3 {
    field TxDqDlyTg3_r8_p0 @0 {
       bits 9;
       access rw;
       reset 9'h10;
    }
  }
  register UseDqsEnReplica_p1 @'h100003 {
    field UseDqsEnReplica_p1 @0 {
       bits 1;
       access rw;
       reset 1'h0;
    }
  }
  register DFIMRL_p1 @'h100020 {
    field DFIMRL_p1 @0 {
       bits 5;
       access rw;
       reset 5'h6;
    }
  }
  register TxImpedanceCtrl0_b0_p1 @'h100041 {
    field DrvStrenDqP @0 {
       bits 6;
       access rw;
       reset 6'h3f;
    }
    field DrvStrenDqN @6 {
       bits 6;
       access rw;
       reset 6'h3f;
    }
  }
  register DqDqsRcvCntrl_b0_p1 @'h100043 {
    field SelAnalogVref @0 {
       bits 1;
       access rw;
       reset 1'h0;
    }
    field ExtVrefRange @1 {
       bits 1;
       access rw;
       reset 1'h0;
    }
    field DfeCtrl @2 {
       bits 2;
       access rw;
       reset 2'h0;
    }
    field MajorModeDbyte @4 {
       bits 3;
       access rw;
       reset 3'h3;
    }
    field GainCurrAdj @7 {
       bits 5;
       access rw;
       reset 5'hb;
    }
    field Reserved @12 {
       bits 4;
    }
  }
  register TxEqualizationMode_p1 @'h100048 {
    field TxEqMode @0 {
       bits 2;
       access rw;
       reset 2'h0;
    }
  }
  register TxImpedanceCtrl1_b0_p1 @'h100049 {
    field DrvStrenFSDqP @0 {
       bits 6;
       access rw;
       reset 6'h3f;
    }
    field DrvStrenFSDqN @6 {
       bits 6;
       access rw;
       reset 6'h3f;
    }
  }
  register TxImpedanceCtrl2_b0_p1 @'h10004b {
    field DrvStrenEQHiDqP @0 {
       bits 6;
       access rw;
       reset 6'h0;
    }
    field DrvStrenEQLoDqN @6 {
       bits 6;
       access rw;
       reset 6'h0;
    }
  }
  register DqDqsRcvCntrl2_p1 @'h10004c {
    field EnRxAgressivePDR @0 {
       bits 1;
       access rw;
       reset 1'h0;
    }
  }
  register TxOdtDrvStren_b0_p1 @'h10004d {
    field ODTStrenP @0 {
       bits 6;
       access rw;
       reset 6'h0;
    }
    field ODTStrenN @6 {
       bits 6;
       access rw;
       reset 6'h0;
    }
  }
  register TxSlewRate_b0_p1 @'h10005f {
    field TxPreP @0 {
       bits 4;
       access rw;
       reset 4'hf;
    }
    field TxPreN @4 {
       bits 4;
       access rw;
       reset 4'hf;
    }
    field TxPreDrvMode @8 {
       bits 3;
       access rw;
       reset 3'h7;
    }
  }
  register RxEnDlyTg0_u0_p1 @'h100080 {
    field RxEnDlyTg0_u0_p1 @0 {
       bits 11;
       access rw;
       reset 11'h100;
    }
  }
  register RxEnDlyTg1_u0_p1 @'h100081 {
    field RxEnDlyTg1_u0_p1 @0 {
       bits 11;
       access rw;
       reset 11'h100;
    }
  }
  register RxEnDlyTg2_u0_p1 @'h100082 {
    field RxEnDlyTg2_u0_p1 @0 {
       bits 11;
       access rw;
       reset 11'h100;
    }
  }
  register RxEnDlyTg3_u0_p1 @'h100083 {
    field RxEnDlyTg3_u0_p1 @0 {
       bits 11;
       access rw;
       reset 11'h100;
    }
  }
  register RxClkDlyTg0_u0_p1 @'h10008c {
    field RxClkDlyTg0_u0_p1 @0 {
       bits 6;
       access rw;
       reset 6'h10;
    }
  }
  register RxClkDlyTg1_u0_p1 @'h10008d {
    field RxClkDlyTg1_u0_p1 @0 {
       bits 6;
       access rw;
       reset 6'h10;
    }
  }
  register RxClkDlyTg2_u0_p1 @'h10008e {
    field RxClkDlyTg2_u0_p1 @0 {
       bits 6;
       access rw;
       reset 6'h10;
    }
  }
  register RxClkDlyTg3_u0_p1 @'h10008f {
    field RxClkDlyTg3_u0_p1 @0 {
       bits 6;
       access rw;
       reset 6'h10;
    }
  }
  register RxClkcDlyTg0_u0_p1 @'h100090 {
    field RxClkcDlyTg0_u0_p1 @0 {
       bits 6;
       access rw;
       reset 6'h10;
    }
  }
  register RxClkcDlyTg1_u0_p1 @'h100091 {
    field RxClkcDlyTg1_u0_p1 @0 {
       bits 6;
       access rw;
       reset 6'h10;
    }
  }
  register RxClkcDlyTg2_u0_p1 @'h100092 {
    field RxClkcDlyTg2_u0_p1 @0 {
       bits 6;
       access rw;
       reset 6'h10;
    }
  }
  register RxClkcDlyTg3_u0_p1 @'h100093 {
    field RxClkcDlyTg3_u0_p1 @0 {
       bits 6;
       access rw;
       reset 6'h10;
    }
  }
  register PptDqsCntInvTrnTg0_p1 @'h1000ae {
    field PptDqsCntInvTrnTg0_p1 @0 {
       bits 16;
       access rw;
       reset 16'h0;
    }
  }
  register PptDqsCntInvTrnTg1_p1 @'h1000af {
    field PptDqsCntInvTrnTg1_p1 @0 {
       bits 16;
       access rw;
       reset 16'h0;
    }
  }
  register TxDqDlyTg0_r0_p1 @'h1000c0 {
    field TxDqDlyTg0_r0_p1 @0 {
       bits 9;
       access rw;
       reset 9'h10;
    }
  }
  register TxDqDlyTg1_r0_p1 @'h1000c1 {
    field TxDqDlyTg1_r0_p1 @0 {
       bits 9;
       access rw;
       reset 9'h10;
    }
  }
  register TxDqDlyTg2_r0_p1 @'h1000c2 {
    field TxDqDlyTg2_r0_p1 @0 {
       bits 9;
       access rw;
       reset 9'h10;
    }
  }
  register TxDqDlyTg3_r0_p1 @'h1000c3 {
    field TxDqDlyTg3_r0_p1 @0 {
       bits 9;
       access rw;
       reset 9'h10;
    }
  }
  register TxDqsDlyTg0_u0_p1 @'h1000d0 {
    field TxDqsDlyTg0_u0_p1 @0 {
       bits 10;
       access rw;
       reset 10'h100;
    }
  }
  register TxDqsDlyTg1_u0_p1 @'h1000d1 {
    field TxDqsDlyTg1_u0_p1 @0 {
       bits 10;
       access rw;
       reset 10'h100;
    }
  }
  register TxDqsDlyTg2_u0_p1 @'h1000d2 {
    field TxDqsDlyTg2_u0_p1 @0 {
       bits 10;
       access rw;
       reset 10'h100;
    }
  }
  register TxDqsDlyTg3_u0_p1 @'h1000d3 {
    field TxDqsDlyTg3_u0_p1 @0 {
       bits 10;
       access rw;
       reset 10'h100;
    }
  }
  register TxImpedanceCtrl0_b1_p1 @'h100141 {
    field DrvStrenDqP @0 {
       bits 6;
       access rw;
       reset 6'h3f;
    }
    field DrvStrenDqN @6 {
       bits 6;
       access rw;
       reset 6'h3f;
    }
  }
  register DqDqsRcvCntrl_b1_p1 @'h100143 {
    field SelAnalogVref @0 {
       bits 1;
       access rw;
       reset 1'h0;
    }
    field ExtVrefRange @1 {
       bits 1;
       access rw;
       reset 1'h0;
    }
    field DfeCtrl @2 {
       bits 2;
       access rw;
       reset 2'h0;
    }
    field MajorModeDbyte @4 {
       bits 3;
       access rw;
       reset 3'h3;
    }
    field GainCurrAdj @7 {
       bits 5;
       access rw;
       reset 5'hb;
    }
    field Reserved @12 {
       bits 4;
    }
  }
  register TxImpedanceCtrl1_b1_p1 @'h100149 {
    field DrvStrenFSDqP @0 {
       bits 6;
       access rw;
       reset 6'h3f;
    }
    field DrvStrenFSDqN @6 {
       bits 6;
       access rw;
       reset 6'h3f;
    }
  }
  register TxImpedanceCtrl2_b1_p1 @'h10014b {
    field DrvStrenEQHiDqP @0 {
       bits 6;
       access rw;
       reset 6'h0;
    }
    field DrvStrenEQLoDqN @6 {
       bits 6;
       access rw;
       reset 6'h0;
    }
  }
  register TxOdtDrvStren_b1_p1 @'h10014d {
    field ODTStrenP @0 {
       bits 6;
       access rw;
       reset 6'h0;
    }
    field ODTStrenN @6 {
       bits 6;
       access rw;
       reset 6'h0;
    }
  }
  register TxSlewRate_b1_p1 @'h10015f {
    field TxPreP @0 {
       bits 4;
       access rw;
       reset 4'hf;
    }
    field TxPreN @4 {
       bits 4;
       access rw;
       reset 4'hf;
    }
    field TxPreDrvMode @8 {
       bits 3;
       access rw;
       reset 3'h7;
    }
  }
  register RxEnDlyTg0_u1_p1 @'h100180 {
    field RxEnDlyTg0_u1_p1 @0 {
       bits 11;
       access rw;
       reset 11'h100;
    }
  }
  register RxEnDlyTg1_u1_p1 @'h100181 {
    field RxEnDlyTg1_u1_p1 @0 {
       bits 11;
       access rw;
       reset 11'h100;
    }
  }
  register RxEnDlyTg2_u1_p1 @'h100182 {
    field RxEnDlyTg2_u1_p1 @0 {
       bits 11;
       access rw;
       reset 11'h100;
    }
  }
  register RxEnDlyTg3_u1_p1 @'h100183 {
    field RxEnDlyTg3_u1_p1 @0 {
       bits 11;
       access rw;
       reset 11'h100;
    }
  }
  register RxClkDlyTg0_u1_p1 @'h10018c {
    field RxClkDlyTg0_u1_p1 @0 {
       bits 6;
       access rw;
       reset 6'h10;
    }
  }
  register RxClkDlyTg1_u1_p1 @'h10018d {
    field RxClkDlyTg1_u1_p1 @0 {
       bits 6;
       access rw;
       reset 6'h10;
    }
  }
  register RxClkDlyTg2_u1_p1 @'h10018e {
    field RxClkDlyTg2_u1_p1 @0 {
       bits 6;
       access rw;
       reset 6'h10;
    }
  }
  register RxClkDlyTg3_u1_p1 @'h10018f {
    field RxClkDlyTg3_u1_p1 @0 {
       bits 6;
       access rw;
       reset 6'h10;
    }
  }
  register RxClkcDlyTg0_u1_p1 @'h100190 {
    field RxClkcDlyTg0_u1_p1 @0 {
       bits 6;
       access rw;
       reset 6'h10;
    }
  }
  register RxClkcDlyTg1_u1_p1 @'h100191 {
    field RxClkcDlyTg1_u1_p1 @0 {
       bits 6;
       access rw;
       reset 6'h10;
    }
  }
  register RxClkcDlyTg2_u1_p1 @'h100192 {
    field RxClkcDlyTg2_u1_p1 @0 {
       bits 6;
       access rw;
       reset 6'h10;
    }
  }
  register RxClkcDlyTg3_u1_p1 @'h100193 {
    field RxClkcDlyTg3_u1_p1 @0 {
       bits 6;
       access rw;
       reset 6'h10;
    }
  }
  register TxDqDlyTg0_r1_p1 @'h1001c0 {
    field TxDqDlyTg0_r1_p1 @0 {
       bits 9;
       access rw;
       reset 9'h10;
    }
  }
  register TxDqDlyTg1_r1_p1 @'h1001c1 {
    field TxDqDlyTg1_r1_p1 @0 {
       bits 9;
       access rw;
       reset 9'h10;
    }
  }
  register TxDqDlyTg2_r1_p1 @'h1001c2 {
    field TxDqDlyTg2_r1_p1 @0 {
       bits 9;
       access rw;
       reset 9'h10;
    }
  }
  register TxDqDlyTg3_r1_p1 @'h1001c3 {
    field TxDqDlyTg3_r1_p1 @0 {
       bits 9;
       access rw;
       reset 9'h10;
    }
  }
  register TxDqsDlyTg0_u1_p1 @'h1001d0 {
    field TxDqsDlyTg0_u1_p1 @0 {
       bits 10;
       access rw;
       reset 10'h100;
    }
  }
  register TxDqsDlyTg1_u1_p1 @'h1001d1 {
    field TxDqsDlyTg1_u1_p1 @0 {
       bits 10;
       access rw;
       reset 10'h100;
    }
  }
  register TxDqsDlyTg2_u1_p1 @'h1001d2 {
    field TxDqsDlyTg2_u1_p1 @0 {
       bits 10;
       access rw;
       reset 10'h100;
    }
  }
  register TxDqsDlyTg3_u1_p1 @'h1001d3 {
    field TxDqsDlyTg3_u1_p1 @0 {
       bits 10;
       access rw;
       reset 10'h100;
    }
  }
  register TxDqDlyTg0_r2_p1 @'h1002c0 {
    field TxDqDlyTg0_r2_p1 @0 {
       bits 9;
       access rw;
       reset 9'h10;
    }
  }
  register TxDqDlyTg1_r2_p1 @'h1002c1 {
    field TxDqDlyTg1_r2_p1 @0 {
       bits 9;
       access rw;
       reset 9'h10;
    }
  }
  register TxDqDlyTg2_r2_p1 @'h1002c2 {
    field TxDqDlyTg2_r2_p1 @0 {
       bits 9;
       access rw;
       reset 9'h10;
    }
  }
  register TxDqDlyTg3_r2_p1 @'h1002c3 {
    field TxDqDlyTg3_r2_p1 @0 {
       bits 9;
       access rw;
       reset 9'h10;
    }
  }
  register TxDqDlyTg0_r3_p1 @'h1003c0 {
    field TxDqDlyTg0_r3_p1 @0 {
       bits 9;
       access rw;
       reset 9'h10;
    }
  }
  register TxDqDlyTg1_r3_p1 @'h1003c1 {
    field TxDqDlyTg1_r3_p1 @0 {
       bits 9;
       access rw;
       reset 9'h10;
    }
  }
  register TxDqDlyTg2_r3_p1 @'h1003c2 {
    field TxDqDlyTg2_r3_p1 @0 {
       bits 9;
       access rw;
       reset 9'h10;
    }
  }
  register TxDqDlyTg3_r3_p1 @'h1003c3 {
    field TxDqDlyTg3_r3_p1 @0 {
       bits 9;
       access rw;
       reset 9'h10;
    }
  }
  register TxDqDlyTg0_r4_p1 @'h1004c0 {
    field TxDqDlyTg0_r4_p1 @0 {
       bits 9;
       access rw;
       reset 9'h10;
    }
  }
  register TxDqDlyTg1_r4_p1 @'h1004c1 {
    field TxDqDlyTg1_r4_p1 @0 {
       bits 9;
       access rw;
       reset 9'h10;
    }
  }
  register TxDqDlyTg2_r4_p1 @'h1004c2 {
    field TxDqDlyTg2_r4_p1 @0 {
       bits 9;
       access rw;
       reset 9'h10;
    }
  }
  register TxDqDlyTg3_r4_p1 @'h1004c3 {
    field TxDqDlyTg3_r4_p1 @0 {
       bits 9;
       access rw;
       reset 9'h10;
    }
  }
  register TxDqDlyTg0_r5_p1 @'h1005c0 {
    field TxDqDlyTg0_r5_p1 @0 {
       bits 9;
       access rw;
       reset 9'h10;
    }
  }
  register TxDqDlyTg1_r5_p1 @'h1005c1 {
    field TxDqDlyTg1_r5_p1 @0 {
       bits 9;
       access rw;
       reset 9'h10;
    }
  }
  register TxDqDlyTg2_r5_p1 @'h1005c2 {
    field TxDqDlyTg2_r5_p1 @0 {
       bits 9;
       access rw;
       reset 9'h10;
    }
  }
  register TxDqDlyTg3_r5_p1 @'h1005c3 {
    field TxDqDlyTg3_r5_p1 @0 {
       bits 9;
       access rw;
       reset 9'h10;
    }
  }
  register TxDqDlyTg0_r6_p1 @'h1006c0 {
    field TxDqDlyTg0_r6_p1 @0 {
       bits 9;
       access rw;
       reset 9'h10;
    }
  }
  register TxDqDlyTg1_r6_p1 @'h1006c1 {
    field TxDqDlyTg1_r6_p1 @0 {
       bits 9;
       access rw;
       reset 9'h10;
    }
  }
  register TxDqDlyTg2_r6_p1 @'h1006c2 {
    field TxDqDlyTg2_r6_p1 @0 {
       bits 9;
       access rw;
       reset 9'h10;
    }
  }
  register TxDqDlyTg3_r6_p1 @'h1006c3 {
    field TxDqDlyTg3_r6_p1 @0 {
       bits 9;
       access rw;
       reset 9'h10;
    }
  }
  register TxDqDlyTg0_r7_p1 @'h1007c0 {
    field TxDqDlyTg0_r7_p1 @0 {
       bits 9;
       access rw;
       reset 9'h10;
    }
  }
  register TxDqDlyTg1_r7_p1 @'h1007c1 {
    field TxDqDlyTg1_r7_p1 @0 {
       bits 9;
       access rw;
       reset 9'h10;
    }
  }
  register TxDqDlyTg2_r7_p1 @'h1007c2 {
    field TxDqDlyTg2_r7_p1 @0 {
       bits 9;
       access rw;
       reset 9'h10;
    }
  }
  register TxDqDlyTg3_r7_p1 @'h1007c3 {
    field TxDqDlyTg3_r7_p1 @0 {
       bits 9;
       access rw;
       reset 9'h10;
    }
  }
  register TxDqDlyTg0_r8_p1 @'h1008c0 {
    field TxDqDlyTg0_r8_p1 @0 {
       bits 9;
       access rw;
       reset 9'h10;
    }
  }
  register TxDqDlyTg1_r8_p1 @'h1008c1 {
    field TxDqDlyTg1_r8_p1 @0 {
       bits 9;
       access rw;
       reset 9'h10;
    }
  }
  register TxDqDlyTg2_r8_p1 @'h1008c2 {
    field TxDqDlyTg2_r8_p1 @0 {
       bits 9;
       access rw;
       reset 9'h10;
    }
  }
  register TxDqDlyTg3_r8_p1 @'h1008c3 {
    field TxDqDlyTg3_r8_p1 @0 {
       bits 9;
       access rw;
       reset 9'h10;
    }
  }
  register UseDqsEnReplica_p2 @'h200003 {
    field UseDqsEnReplica_p2 @0 {
       bits 1;
       access rw;
       reset 1'h0;
    }
  }
  register DFIMRL_p2 @'h200020 {
    field DFIMRL_p2 @0 {
       bits 5;
       access rw;
       reset 5'h6;
    }
  }
  register TxImpedanceCtrl0_b0_p2 @'h200041 {
    field DrvStrenDqP @0 {
       bits 6;
       access rw;
       reset 6'h3f;
    }
    field DrvStrenDqN @6 {
       bits 6;
       access rw;
       reset 6'h3f;
    }
  }
  register DqDqsRcvCntrl_b0_p2 @'h200043 {
    field SelAnalogVref @0 {
       bits 1;
       access rw;
       reset 1'h0;
    }
    field ExtVrefRange @1 {
       bits 1;
       access rw;
       reset 1'h0;
    }
    field DfeCtrl @2 {
       bits 2;
       access rw;
       reset 2'h0;
    }
    field MajorModeDbyte @4 {
       bits 3;
       access rw;
       reset 3'h3;
    }
    field GainCurrAdj @7 {
       bits 5;
       access rw;
       reset 5'hb;
    }
    field Reserved @12 {
       bits 4;
    }
  }
  register TxEqualizationMode_p2 @'h200048 {
    field TxEqMode @0 {
       bits 2;
       access rw;
       reset 2'h0;
    }
  }
  register TxImpedanceCtrl1_b0_p2 @'h200049 {
    field DrvStrenFSDqP @0 {
       bits 6;
       access rw;
       reset 6'h3f;
    }
    field DrvStrenFSDqN @6 {
       bits 6;
       access rw;
       reset 6'h3f;
    }
  }
  register TxImpedanceCtrl2_b0_p2 @'h20004b {
    field DrvStrenEQHiDqP @0 {
       bits 6;
       access rw;
       reset 6'h0;
    }
    field DrvStrenEQLoDqN @6 {
       bits 6;
       access rw;
       reset 6'h0;
    }
  }
  register DqDqsRcvCntrl2_p2 @'h20004c {
    field EnRxAgressivePDR @0 {
       bits 1;
       access rw;
       reset 1'h0;
    }
  }
  register TxOdtDrvStren_b0_p2 @'h20004d {
    field ODTStrenP @0 {
       bits 6;
       access rw;
       reset 6'h0;
    }
    field ODTStrenN @6 {
       bits 6;
       access rw;
       reset 6'h0;
    }
  }
  register TxSlewRate_b0_p2 @'h20005f {
    field TxPreP @0 {
       bits 4;
       access rw;
       reset 4'hf;
    }
    field TxPreN @4 {
       bits 4;
       access rw;
       reset 4'hf;
    }
    field TxPreDrvMode @8 {
       bits 3;
       access rw;
       reset 3'h7;
    }
  }
  register RxEnDlyTg0_u0_p2 @'h200080 {
    field RxEnDlyTg0_u0_p2 @0 {
       bits 11;
       access rw;
       reset 11'h100;
    }
  }
  register RxEnDlyTg1_u0_p2 @'h200081 {
    field RxEnDlyTg1_u0_p2 @0 {
       bits 11;
       access rw;
       reset 11'h100;
    }
  }
  register RxEnDlyTg2_u0_p2 @'h200082 {
    field RxEnDlyTg2_u0_p2 @0 {
       bits 11;
       access rw;
       reset 11'h100;
    }
  }
  register RxEnDlyTg3_u0_p2 @'h200083 {
    field RxEnDlyTg3_u0_p2 @0 {
       bits 11;
       access rw;
       reset 11'h100;
    }
  }
  register RxClkDlyTg0_u0_p2 @'h20008c {
    field RxClkDlyTg0_u0_p2 @0 {
       bits 6;
       access rw;
       reset 6'h10;
    }
  }
  register RxClkDlyTg1_u0_p2 @'h20008d {
    field RxClkDlyTg1_u0_p2 @0 {
       bits 6;
       access rw;
       reset 6'h10;
    }
  }
  register RxClkDlyTg2_u0_p2 @'h20008e {
    field RxClkDlyTg2_u0_p2 @0 {
       bits 6;
       access rw;
       reset 6'h10;
    }
  }
  register RxClkDlyTg3_u0_p2 @'h20008f {
    field RxClkDlyTg3_u0_p2 @0 {
       bits 6;
       access rw;
       reset 6'h10;
    }
  }
  register RxClkcDlyTg0_u0_p2 @'h200090 {
    field RxClkcDlyTg0_u0_p2 @0 {
       bits 6;
       access rw;
       reset 6'h10;
    }
  }
  register RxClkcDlyTg1_u0_p2 @'h200091 {
    field RxClkcDlyTg1_u0_p2 @0 {
       bits 6;
       access rw;
       reset 6'h10;
    }
  }
  register RxClkcDlyTg2_u0_p2 @'h200092 {
    field RxClkcDlyTg2_u0_p2 @0 {
       bits 6;
       access rw;
       reset 6'h10;
    }
  }
  register RxClkcDlyTg3_u0_p2 @'h200093 {
    field RxClkcDlyTg3_u0_p2 @0 {
       bits 6;
       access rw;
       reset 6'h10;
    }
  }
  register PptDqsCntInvTrnTg0_p2 @'h2000ae {
    field PptDqsCntInvTrnTg0_p2 @0 {
       bits 16;
       access rw;
       reset 16'h0;
    }
  }
  register PptDqsCntInvTrnTg1_p2 @'h2000af {
    field PptDqsCntInvTrnTg1_p2 @0 {
       bits 16;
       access rw;
       reset 16'h0;
    }
  }
  register TxDqDlyTg0_r0_p2 @'h2000c0 {
    field TxDqDlyTg0_r0_p2 @0 {
       bits 9;
       access rw;
       reset 9'h10;
    }
  }
  register TxDqDlyTg1_r0_p2 @'h2000c1 {
    field TxDqDlyTg1_r0_p2 @0 {
       bits 9;
       access rw;
       reset 9'h10;
    }
  }
  register TxDqDlyTg2_r0_p2 @'h2000c2 {
    field TxDqDlyTg2_r0_p2 @0 {
       bits 9;
       access rw;
       reset 9'h10;
    }
  }
  register TxDqDlyTg3_r0_p2 @'h2000c3 {
    field TxDqDlyTg3_r0_p2 @0 {
       bits 9;
       access rw;
       reset 9'h10;
    }
  }
  register TxDqsDlyTg0_u0_p2 @'h2000d0 {
    field TxDqsDlyTg0_u0_p2 @0 {
       bits 10;
       access rw;
       reset 10'h100;
    }
  }
  register TxDqsDlyTg1_u0_p2 @'h2000d1 {
    field TxDqsDlyTg1_u0_p2 @0 {
       bits 10;
       access rw;
       reset 10'h100;
    }
  }
  register TxDqsDlyTg2_u0_p2 @'h2000d2 {
    field TxDqsDlyTg2_u0_p2 @0 {
       bits 10;
       access rw;
       reset 10'h100;
    }
  }
  register TxDqsDlyTg3_u0_p2 @'h2000d3 {
    field TxDqsDlyTg3_u0_p2 @0 {
       bits 10;
       access rw;
       reset 10'h100;
    }
  }
  register TxImpedanceCtrl0_b1_p2 @'h200141 {
    field DrvStrenDqP @0 {
       bits 6;
       access rw;
       reset 6'h3f;
    }
    field DrvStrenDqN @6 {
       bits 6;
       access rw;
       reset 6'h3f;
    }
  }
  register DqDqsRcvCntrl_b1_p2 @'h200143 {
    field SelAnalogVref @0 {
       bits 1;
       access rw;
       reset 1'h0;
    }
    field ExtVrefRange @1 {
       bits 1;
       access rw;
       reset 1'h0;
    }
    field DfeCtrl @2 {
       bits 2;
       access rw;
       reset 2'h0;
    }
    field MajorModeDbyte @4 {
       bits 3;
       access rw;
       reset 3'h3;
    }
    field GainCurrAdj @7 {
       bits 5;
       access rw;
       reset 5'hb;
    }
    field Reserved @12 {
       bits 4;
    }
  }
  register TxImpedanceCtrl1_b1_p2 @'h200149 {
    field DrvStrenFSDqP @0 {
       bits 6;
       access rw;
       reset 6'h3f;
    }
    field DrvStrenFSDqN @6 {
       bits 6;
       access rw;
       reset 6'h3f;
    }
  }
  register TxImpedanceCtrl2_b1_p2 @'h20014b {
    field DrvStrenEQHiDqP @0 {
       bits 6;
       access rw;
       reset 6'h0;
    }
    field DrvStrenEQLoDqN @6 {
       bits 6;
       access rw;
       reset 6'h0;
    }
  }
  register TxOdtDrvStren_b1_p2 @'h20014d {
    field ODTStrenP @0 {
       bits 6;
       access rw;
       reset 6'h0;
    }
    field ODTStrenN @6 {
       bits 6;
       access rw;
       reset 6'h0;
    }
  }
  register TxSlewRate_b1_p2 @'h20015f {
    field TxPreP @0 {
       bits 4;
       access rw;
       reset 4'hf;
    }
    field TxPreN @4 {
       bits 4;
       access rw;
       reset 4'hf;
    }
    field TxPreDrvMode @8 {
       bits 3;
       access rw;
       reset 3'h7;
    }
  }
  register RxEnDlyTg0_u1_p2 @'h200180 {
    field RxEnDlyTg0_u1_p2 @0 {
       bits 11;
       access rw;
       reset 11'h100;
    }
  }
  register RxEnDlyTg1_u1_p2 @'h200181 {
    field RxEnDlyTg1_u1_p2 @0 {
       bits 11;
       access rw;
       reset 11'h100;
    }
  }
  register RxEnDlyTg2_u1_p2 @'h200182 {
    field RxEnDlyTg2_u1_p2 @0 {
       bits 11;
       access rw;
       reset 11'h100;
    }
  }
  register RxEnDlyTg3_u1_p2 @'h200183 {
    field RxEnDlyTg3_u1_p2 @0 {
       bits 11;
       access rw;
       reset 11'h100;
    }
  }
  register RxClkDlyTg0_u1_p2 @'h20018c {
    field RxClkDlyTg0_u1_p2 @0 {
       bits 6;
       access rw;
       reset 6'h10;
    }
  }
  register RxClkDlyTg1_u1_p2 @'h20018d {
    field RxClkDlyTg1_u1_p2 @0 {
       bits 6;
       access rw;
       reset 6'h10;
    }
  }
  register RxClkDlyTg2_u1_p2 @'h20018e {
    field RxClkDlyTg2_u1_p2 @0 {
       bits 6;
       access rw;
       reset 6'h10;
    }
  }
  register RxClkDlyTg3_u1_p2 @'h20018f {
    field RxClkDlyTg3_u1_p2 @0 {
       bits 6;
       access rw;
       reset 6'h10;
    }
  }
  register RxClkcDlyTg0_u1_p2 @'h200190 {
    field RxClkcDlyTg0_u1_p2 @0 {
       bits 6;
       access rw;
       reset 6'h10;
    }
  }
  register RxClkcDlyTg1_u1_p2 @'h200191 {
    field RxClkcDlyTg1_u1_p2 @0 {
       bits 6;
       access rw;
       reset 6'h10;
    }
  }
  register RxClkcDlyTg2_u1_p2 @'h200192 {
    field RxClkcDlyTg2_u1_p2 @0 {
       bits 6;
       access rw;
       reset 6'h10;
    }
  }
  register RxClkcDlyTg3_u1_p2 @'h200193 {
    field RxClkcDlyTg3_u1_p2 @0 {
       bits 6;
       access rw;
       reset 6'h10;
    }
  }
  register TxDqDlyTg0_r1_p2 @'h2001c0 {
    field TxDqDlyTg0_r1_p2 @0 {
       bits 9;
       access rw;
       reset 9'h10;
    }
  }
  register TxDqDlyTg1_r1_p2 @'h2001c1 {
    field TxDqDlyTg1_r1_p2 @0 {
       bits 9;
       access rw;
       reset 9'h10;
    }
  }
  register TxDqDlyTg2_r1_p2 @'h2001c2 {
    field TxDqDlyTg2_r1_p2 @0 {
       bits 9;
       access rw;
       reset 9'h10;
    }
  }
  register TxDqDlyTg3_r1_p2 @'h2001c3 {
    field TxDqDlyTg3_r1_p2 @0 {
       bits 9;
       access rw;
       reset 9'h10;
    }
  }
  register TxDqsDlyTg0_u1_p2 @'h2001d0 {
    field TxDqsDlyTg0_u1_p2 @0 {
       bits 10;
       access rw;
       reset 10'h100;
    }
  }
  register TxDqsDlyTg1_u1_p2 @'h2001d1 {
    field TxDqsDlyTg1_u1_p2 @0 {
       bits 10;
       access rw;
       reset 10'h100;
    }
  }
  register TxDqsDlyTg2_u1_p2 @'h2001d2 {
    field TxDqsDlyTg2_u1_p2 @0 {
       bits 10;
       access rw;
       reset 10'h100;
    }
  }
  register TxDqsDlyTg3_u1_p2 @'h2001d3 {
    field TxDqsDlyTg3_u1_p2 @0 {
       bits 10;
       access rw;
       reset 10'h100;
    }
  }
  register TxDqDlyTg0_r2_p2 @'h2002c0 {
    field TxDqDlyTg0_r2_p2 @0 {
       bits 9;
       access rw;
       reset 9'h10;
    }
  }
  register TxDqDlyTg1_r2_p2 @'h2002c1 {
    field TxDqDlyTg1_r2_p2 @0 {
       bits 9;
       access rw;
       reset 9'h10;
    }
  }
  register TxDqDlyTg2_r2_p2 @'h2002c2 {
    field TxDqDlyTg2_r2_p2 @0 {
       bits 9;
       access rw;
       reset 9'h10;
    }
  }
  register TxDqDlyTg3_r2_p2 @'h2002c3 {
    field TxDqDlyTg3_r2_p2 @0 {
       bits 9;
       access rw;
       reset 9'h10;
    }
  }
  register TxDqDlyTg0_r3_p2 @'h2003c0 {
    field TxDqDlyTg0_r3_p2 @0 {
       bits 9;
       access rw;
       reset 9'h10;
    }
  }
  register TxDqDlyTg1_r3_p2 @'h2003c1 {
    field TxDqDlyTg1_r3_p2 @0 {
       bits 9;
       access rw;
       reset 9'h10;
    }
  }
  register TxDqDlyTg2_r3_p2 @'h2003c2 {
    field TxDqDlyTg2_r3_p2 @0 {
       bits 9;
       access rw;
       reset 9'h10;
    }
  }
  register TxDqDlyTg3_r3_p2 @'h2003c3 {
    field TxDqDlyTg3_r3_p2 @0 {
       bits 9;
       access rw;
       reset 9'h10;
    }
  }
  register TxDqDlyTg0_r4_p2 @'h2004c0 {
    field TxDqDlyTg0_r4_p2 @0 {
       bits 9;
       access rw;
       reset 9'h10;
    }
  }
  register TxDqDlyTg1_r4_p2 @'h2004c1 {
    field TxDqDlyTg1_r4_p2 @0 {
       bits 9;
       access rw;
       reset 9'h10;
    }
  }
  register TxDqDlyTg2_r4_p2 @'h2004c2 {
    field TxDqDlyTg2_r4_p2 @0 {
       bits 9;
       access rw;
       reset 9'h10;
    }
  }
  register TxDqDlyTg3_r4_p2 @'h2004c3 {
    field TxDqDlyTg3_r4_p2 @0 {
       bits 9;
       access rw;
       reset 9'h10;
    }
  }
  register TxDqDlyTg0_r5_p2 @'h2005c0 {
    field TxDqDlyTg0_r5_p2 @0 {
       bits 9;
       access rw;
       reset 9'h10;
    }
  }
  register TxDqDlyTg1_r5_p2 @'h2005c1 {
    field TxDqDlyTg1_r5_p2 @0 {
       bits 9;
       access rw;
       reset 9'h10;
    }
  }
  register TxDqDlyTg2_r5_p2 @'h2005c2 {
    field TxDqDlyTg2_r5_p2 @0 {
       bits 9;
       access rw;
       reset 9'h10;
    }
  }
  register TxDqDlyTg3_r5_p2 @'h2005c3 {
    field TxDqDlyTg3_r5_p2 @0 {
       bits 9;
       access rw;
       reset 9'h10;
    }
  }
  register TxDqDlyTg0_r6_p2 @'h2006c0 {
    field TxDqDlyTg0_r6_p2 @0 {
       bits 9;
       access rw;
       reset 9'h10;
    }
  }
  register TxDqDlyTg1_r6_p2 @'h2006c1 {
    field TxDqDlyTg1_r6_p2 @0 {
       bits 9;
       access rw;
       reset 9'h10;
    }
  }
  register TxDqDlyTg2_r6_p2 @'h2006c2 {
    field TxDqDlyTg2_r6_p2 @0 {
       bits 9;
       access rw;
       reset 9'h10;
    }
  }
  register TxDqDlyTg3_r6_p2 @'h2006c3 {
    field TxDqDlyTg3_r6_p2 @0 {
       bits 9;
       access rw;
       reset 9'h10;
    }
  }
  register TxDqDlyTg0_r7_p2 @'h2007c0 {
    field TxDqDlyTg0_r7_p2 @0 {
       bits 9;
       access rw;
       reset 9'h10;
    }
  }
  register TxDqDlyTg1_r7_p2 @'h2007c1 {
    field TxDqDlyTg1_r7_p2 @0 {
       bits 9;
       access rw;
       reset 9'h10;
    }
  }
  register TxDqDlyTg2_r7_p2 @'h2007c2 {
    field TxDqDlyTg2_r7_p2 @0 {
       bits 9;
       access rw;
       reset 9'h10;
    }
  }
  register TxDqDlyTg3_r7_p2 @'h2007c3 {
    field TxDqDlyTg3_r7_p2 @0 {
       bits 9;
       access rw;
       reset 9'h10;
    }
  }
  register TxDqDlyTg0_r8_p2 @'h2008c0 {
    field TxDqDlyTg0_r8_p2 @0 {
       bits 9;
       access rw;
       reset 9'h10;
    }
  }
  register TxDqDlyTg1_r8_p2 @'h2008c1 {
    field TxDqDlyTg1_r8_p2 @0 {
       bits 9;
       access rw;
       reset 9'h10;
    }
  }
  register TxDqDlyTg2_r8_p2 @'h2008c2 {
    field TxDqDlyTg2_r8_p2 @0 {
       bits 9;
       access rw;
       reset 9'h10;
    }
  }
  register TxDqDlyTg3_r8_p2 @'h2008c3 {
    field TxDqDlyTg3_r8_p2 @0 {
       bits 9;
       access rw;
       reset 9'h10;
    }
  }
  register UseDqsEnReplica_p3 @'h300003 {
    field UseDqsEnReplica_p3 @0 {
       bits 1;
       access rw;
       reset 1'h0;
    }
  }
  register DFIMRL_p3 @'h300020 {
    field DFIMRL_p3 @0 {
       bits 5;
       access rw;
       reset 5'h6;
    }
  }
  register TxImpedanceCtrl0_b0_p3 @'h300041 {
    field DrvStrenDqP @0 {
       bits 6;
       access rw;
       reset 6'h3f;
    }
    field DrvStrenDqN @6 {
       bits 6;
       access rw;
       reset 6'h3f;
    }
  }
  register DqDqsRcvCntrl_b0_p3 @'h300043 {
    field SelAnalogVref @0 {
       bits 1;
       access rw;
       reset 1'h0;
    }
    field ExtVrefRange @1 {
       bits 1;
       access rw;
       reset 1'h0;
    }
    field DfeCtrl @2 {
       bits 2;
       access rw;
       reset 2'h0;
    }
    field MajorModeDbyte @4 {
       bits 3;
       access rw;
       reset 3'h3;
    }
    field GainCurrAdj @7 {
       bits 5;
       access rw;
       reset 5'hb;
    }
    field Reserved @12 {
       bits 4;
    }
  }
  register TxEqualizationMode_p3 @'h300048 {
    field TxEqMode @0 {
       bits 2;
       access rw;
       reset 2'h0;
    }
  }
  register TxImpedanceCtrl1_b0_p3 @'h300049 {
    field DrvStrenFSDqP @0 {
       bits 6;
       access rw;
       reset 6'h3f;
    }
    field DrvStrenFSDqN @6 {
       bits 6;
       access rw;
       reset 6'h3f;
    }
  }
  register TxImpedanceCtrl2_b0_p3 @'h30004b {
    field DrvStrenEQHiDqP @0 {
       bits 6;
       access rw;
       reset 6'h0;
    }
    field DrvStrenEQLoDqN @6 {
       bits 6;
       access rw;
       reset 6'h0;
    }
  }
  register DqDqsRcvCntrl2_p3 @'h30004c {
    field EnRxAgressivePDR @0 {
       bits 1;
       access rw;
       reset 1'h0;
    }
  }
  register TxOdtDrvStren_b0_p3 @'h30004d {
    field ODTStrenP @0 {
       bits 6;
       access rw;
       reset 6'h0;
    }
    field ODTStrenN @6 {
       bits 6;
       access rw;
       reset 6'h0;
    }
  }
  register TxSlewRate_b0_p3 @'h30005f {
    field TxPreP @0 {
       bits 4;
       access rw;
       reset 4'hf;
    }
    field TxPreN @4 {
       bits 4;
       access rw;
       reset 4'hf;
    }
    field TxPreDrvMode @8 {
       bits 3;
       access rw;
       reset 3'h7;
    }
  }
  register RxEnDlyTg0_u0_p3 @'h300080 {
    field RxEnDlyTg0_u0_p3 @0 {
       bits 11;
       access rw;
       reset 11'h100;
    }
  }
  register RxEnDlyTg1_u0_p3 @'h300081 {
    field RxEnDlyTg1_u0_p3 @0 {
       bits 11;
       access rw;
       reset 11'h100;
    }
  }
  register RxEnDlyTg2_u0_p3 @'h300082 {
    field RxEnDlyTg2_u0_p3 @0 {
       bits 11;
       access rw;
       reset 11'h100;
    }
  }
  register RxEnDlyTg3_u0_p3 @'h300083 {
    field RxEnDlyTg3_u0_p3 @0 {
       bits 11;
       access rw;
       reset 11'h100;
    }
  }
  register RxClkDlyTg0_u0_p3 @'h30008c {
    field RxClkDlyTg0_u0_p3 @0 {
       bits 6;
       access rw;
       reset 6'h10;
    }
  }
  register RxClkDlyTg1_u0_p3 @'h30008d {
    field RxClkDlyTg1_u0_p3 @0 {
       bits 6;
       access rw;
       reset 6'h10;
    }
  }
  register RxClkDlyTg2_u0_p3 @'h30008e {
    field RxClkDlyTg2_u0_p3 @0 {
       bits 6;
       access rw;
       reset 6'h10;
    }
  }
  register RxClkDlyTg3_u0_p3 @'h30008f {
    field RxClkDlyTg3_u0_p3 @0 {
       bits 6;
       access rw;
       reset 6'h10;
    }
  }
  register RxClkcDlyTg0_u0_p3 @'h300090 {
    field RxClkcDlyTg0_u0_p3 @0 {
       bits 6;
       access rw;
       reset 6'h10;
    }
  }
  register RxClkcDlyTg1_u0_p3 @'h300091 {
    field RxClkcDlyTg1_u0_p3 @0 {
       bits 6;
       access rw;
       reset 6'h10;
    }
  }
  register RxClkcDlyTg2_u0_p3 @'h300092 {
    field RxClkcDlyTg2_u0_p3 @0 {
       bits 6;
       access rw;
       reset 6'h10;
    }
  }
  register RxClkcDlyTg3_u0_p3 @'h300093 {
    field RxClkcDlyTg3_u0_p3 @0 {
       bits 6;
       access rw;
       reset 6'h10;
    }
  }
  register PptDqsCntInvTrnTg0_p3 @'h3000ae {
    field PptDqsCntInvTrnTg0_p3 @0 {
       bits 16;
       access rw;
       reset 16'h0;
    }
  }
  register PptDqsCntInvTrnTg1_p3 @'h3000af {
    field PptDqsCntInvTrnTg1_p3 @0 {
       bits 16;
       access rw;
       reset 16'h0;
    }
  }
  register TxDqDlyTg0_r0_p3 @'h3000c0 {
    field TxDqDlyTg0_r0_p3 @0 {
       bits 9;
       access rw;
       reset 9'h10;
    }
  }
  register TxDqDlyTg1_r0_p3 @'h3000c1 {
    field TxDqDlyTg1_r0_p3 @0 {
       bits 9;
       access rw;
       reset 9'h10;
    }
  }
  register TxDqDlyTg2_r0_p3 @'h3000c2 {
    field TxDqDlyTg2_r0_p3 @0 {
       bits 9;
       access rw;
       reset 9'h10;
    }
  }
  register TxDqDlyTg3_r0_p3 @'h3000c3 {
    field TxDqDlyTg3_r0_p3 @0 {
       bits 9;
       access rw;
       reset 9'h10;
    }
  }
  register TxDqsDlyTg0_u0_p3 @'h3000d0 {
    field TxDqsDlyTg0_u0_p3 @0 {
       bits 10;
       access rw;
       reset 10'h100;
    }
  }
  register TxDqsDlyTg1_u0_p3 @'h3000d1 {
    field TxDqsDlyTg1_u0_p3 @0 {
       bits 10;
       access rw;
       reset 10'h100;
    }
  }
  register TxDqsDlyTg2_u0_p3 @'h3000d2 {
    field TxDqsDlyTg2_u0_p3 @0 {
       bits 10;
       access rw;
       reset 10'h100;
    }
  }
  register TxDqsDlyTg3_u0_p3 @'h3000d3 {
    field TxDqsDlyTg3_u0_p3 @0 {
       bits 10;
       access rw;
       reset 10'h100;
    }
  }
  register TxImpedanceCtrl0_b1_p3 @'h300141 {
    field DrvStrenDqP @0 {
       bits 6;
       access rw;
       reset 6'h3f;
    }
    field DrvStrenDqN @6 {
       bits 6;
       access rw;
       reset 6'h3f;
    }
  }
  register DqDqsRcvCntrl_b1_p3 @'h300143 {
    field SelAnalogVref @0 {
       bits 1;
       access rw;
       reset 1'h0;
    }
    field ExtVrefRange @1 {
       bits 1;
       access rw;
       reset 1'h0;
    }
    field DfeCtrl @2 {
       bits 2;
       access rw;
       reset 2'h0;
    }
    field MajorModeDbyte @4 {
       bits 3;
       access rw;
       reset 3'h3;
    }
    field GainCurrAdj @7 {
       bits 5;
       access rw;
       reset 5'hb;
    }
    field Reserved @12 {
       bits 4;
    }
  }
  register TxImpedanceCtrl1_b1_p3 @'h300149 {
    field DrvStrenFSDqP @0 {
       bits 6;
       access rw;
       reset 6'h3f;
    }
    field DrvStrenFSDqN @6 {
       bits 6;
       access rw;
       reset 6'h3f;
    }
  }
  register TxImpedanceCtrl2_b1_p3 @'h30014b {
    field DrvStrenEQHiDqP @0 {
       bits 6;
       access rw;
       reset 6'h0;
    }
    field DrvStrenEQLoDqN @6 {
       bits 6;
       access rw;
       reset 6'h0;
    }
  }
  register TxOdtDrvStren_b1_p3 @'h30014d {
    field ODTStrenP @0 {
       bits 6;
       access rw;
       reset 6'h0;
    }
    field ODTStrenN @6 {
       bits 6;
       access rw;
       reset 6'h0;
    }
  }
  register TxSlewRate_b1_p3 @'h30015f {
    field TxPreP @0 {
       bits 4;
       access rw;
       reset 4'hf;
    }
    field TxPreN @4 {
       bits 4;
       access rw;
       reset 4'hf;
    }
    field TxPreDrvMode @8 {
       bits 3;
       access rw;
       reset 3'h7;
    }
  }
  register RxEnDlyTg0_u1_p3 @'h300180 {
    field RxEnDlyTg0_u1_p3 @0 {
       bits 11;
       access rw;
       reset 11'h100;
    }
  }
  register RxEnDlyTg1_u1_p3 @'h300181 {
    field RxEnDlyTg1_u1_p3 @0 {
       bits 11;
       access rw;
       reset 11'h100;
    }
  }
  register RxEnDlyTg2_u1_p3 @'h300182 {
    field RxEnDlyTg2_u1_p3 @0 {
       bits 11;
       access rw;
       reset 11'h100;
    }
  }
  register RxEnDlyTg3_u1_p3 @'h300183 {
    field RxEnDlyTg3_u1_p3 @0 {
       bits 11;
       access rw;
       reset 11'h100;
    }
  }
  register RxClkDlyTg0_u1_p3 @'h30018c {
    field RxClkDlyTg0_u1_p3 @0 {
       bits 6;
       access rw;
       reset 6'h10;
    }
  }
  register RxClkDlyTg1_u1_p3 @'h30018d {
    field RxClkDlyTg1_u1_p3 @0 {
       bits 6;
       access rw;
       reset 6'h10;
    }
  }
  register RxClkDlyTg2_u1_p3 @'h30018e {
    field RxClkDlyTg2_u1_p3 @0 {
       bits 6;
       access rw;
       reset 6'h10;
    }
  }
  register RxClkDlyTg3_u1_p3 @'h30018f {
    field RxClkDlyTg3_u1_p3 @0 {
       bits 6;
       access rw;
       reset 6'h10;
    }
  }
  register RxClkcDlyTg0_u1_p3 @'h300190 {
    field RxClkcDlyTg0_u1_p3 @0 {
       bits 6;
       access rw;
       reset 6'h10;
    }
  }
  register RxClkcDlyTg1_u1_p3 @'h300191 {
    field RxClkcDlyTg1_u1_p3 @0 {
       bits 6;
       access rw;
       reset 6'h10;
    }
  }
  register RxClkcDlyTg2_u1_p3 @'h300192 {
    field RxClkcDlyTg2_u1_p3 @0 {
       bits 6;
       access rw;
       reset 6'h10;
    }
  }
  register RxClkcDlyTg3_u1_p3 @'h300193 {
    field RxClkcDlyTg3_u1_p3 @0 {
       bits 6;
       access rw;
       reset 6'h10;
    }
  }
  register TxDqDlyTg0_r1_p3 @'h3001c0 {
    field TxDqDlyTg0_r1_p3 @0 {
       bits 9;
       access rw;
       reset 9'h10;
    }
  }
  register TxDqDlyTg1_r1_p3 @'h3001c1 {
    field TxDqDlyTg1_r1_p3 @0 {
       bits 9;
       access rw;
       reset 9'h10;
    }
  }
  register TxDqDlyTg2_r1_p3 @'h3001c2 {
    field TxDqDlyTg2_r1_p3 @0 {
       bits 9;
       access rw;
       reset 9'h10;
    }
  }
  register TxDqDlyTg3_r1_p3 @'h3001c3 {
    field TxDqDlyTg3_r1_p3 @0 {
       bits 9;
       access rw;
       reset 9'h10;
    }
  }
  register TxDqsDlyTg0_u1_p3 @'h3001d0 {
    field TxDqsDlyTg0_u1_p3 @0 {
       bits 10;
       access rw;
       reset 10'h100;
    }
  }
  register TxDqsDlyTg1_u1_p3 @'h3001d1 {
    field TxDqsDlyTg1_u1_p3 @0 {
       bits 10;
       access rw;
       reset 10'h100;
    }
  }
  register TxDqsDlyTg2_u1_p3 @'h3001d2 {
    field TxDqsDlyTg2_u1_p3 @0 {
       bits 10;
       access rw;
       reset 10'h100;
    }
  }
  register TxDqsDlyTg3_u1_p3 @'h3001d3 {
    field TxDqsDlyTg3_u1_p3 @0 {
       bits 10;
       access rw;
       reset 10'h100;
    }
  }
  register TxDqDlyTg0_r2_p3 @'h3002c0 {
    field TxDqDlyTg0_r2_p3 @0 {
       bits 9;
       access rw;
       reset 9'h10;
    }
  }
  register TxDqDlyTg1_r2_p3 @'h3002c1 {
    field TxDqDlyTg1_r2_p3 @0 {
       bits 9;
       access rw;
       reset 9'h10;
    }
  }
  register TxDqDlyTg2_r2_p3 @'h3002c2 {
    field TxDqDlyTg2_r2_p3 @0 {
       bits 9;
       access rw;
       reset 9'h10;
    }
  }
  register TxDqDlyTg3_r2_p3 @'h3002c3 {
    field TxDqDlyTg3_r2_p3 @0 {
       bits 9;
       access rw;
       reset 9'h10;
    }
  }
  register TxDqDlyTg0_r3_p3 @'h3003c0 {
    field TxDqDlyTg0_r3_p3 @0 {
       bits 9;
       access rw;
       reset 9'h10;
    }
  }
  register TxDqDlyTg1_r3_p3 @'h3003c1 {
    field TxDqDlyTg1_r3_p3 @0 {
       bits 9;
       access rw;
       reset 9'h10;
    }
  }
  register TxDqDlyTg2_r3_p3 @'h3003c2 {
    field TxDqDlyTg2_r3_p3 @0 {
       bits 9;
       access rw;
       reset 9'h10;
    }
  }
  register TxDqDlyTg3_r3_p3 @'h3003c3 {
    field TxDqDlyTg3_r3_p3 @0 {
       bits 9;
       access rw;
       reset 9'h10;
    }
  }
  register TxDqDlyTg0_r4_p3 @'h3004c0 {
    field TxDqDlyTg0_r4_p3 @0 {
       bits 9;
       access rw;
       reset 9'h10;
    }
  }
  register TxDqDlyTg1_r4_p3 @'h3004c1 {
    field TxDqDlyTg1_r4_p3 @0 {
       bits 9;
       access rw;
       reset 9'h10;
    }
  }
  register TxDqDlyTg2_r4_p3 @'h3004c2 {
    field TxDqDlyTg2_r4_p3 @0 {
       bits 9;
       access rw;
       reset 9'h10;
    }
  }
  register TxDqDlyTg3_r4_p3 @'h3004c3 {
    field TxDqDlyTg3_r4_p3 @0 {
       bits 9;
       access rw;
       reset 9'h10;
    }
  }
  register TxDqDlyTg0_r5_p3 @'h3005c0 {
    field TxDqDlyTg0_r5_p3 @0 {
       bits 9;
       access rw;
       reset 9'h10;
    }
  }
  register TxDqDlyTg1_r5_p3 @'h3005c1 {
    field TxDqDlyTg1_r5_p3 @0 {
       bits 9;
       access rw;
       reset 9'h10;
    }
  }
  register TxDqDlyTg2_r5_p3 @'h3005c2 {
    field TxDqDlyTg2_r5_p3 @0 {
       bits 9;
       access rw;
       reset 9'h10;
    }
  }
  register TxDqDlyTg3_r5_p3 @'h3005c3 {
    field TxDqDlyTg3_r5_p3 @0 {
       bits 9;
       access rw;
       reset 9'h10;
    }
  }
  register TxDqDlyTg0_r6_p3 @'h3006c0 {
    field TxDqDlyTg0_r6_p3 @0 {
       bits 9;
       access rw;
       reset 9'h10;
    }
  }
  register TxDqDlyTg1_r6_p3 @'h3006c1 {
    field TxDqDlyTg1_r6_p3 @0 {
       bits 9;
       access rw;
       reset 9'h10;
    }
  }
  register TxDqDlyTg2_r6_p3 @'h3006c2 {
    field TxDqDlyTg2_r6_p3 @0 {
       bits 9;
       access rw;
       reset 9'h10;
    }
  }
  register TxDqDlyTg3_r6_p3 @'h3006c3 {
    field TxDqDlyTg3_r6_p3 @0 {
       bits 9;
       access rw;
       reset 9'h10;
    }
  }
  register TxDqDlyTg0_r7_p3 @'h3007c0 {
    field TxDqDlyTg0_r7_p3 @0 {
       bits 9;
       access rw;
       reset 9'h10;
    }
  }
  register TxDqDlyTg1_r7_p3 @'h3007c1 {
    field TxDqDlyTg1_r7_p3 @0 {
       bits 9;
       access rw;
       reset 9'h10;
    }
  }
  register TxDqDlyTg2_r7_p3 @'h3007c2 {
    field TxDqDlyTg2_r7_p3 @0 {
       bits 9;
       access rw;
       reset 9'h10;
    }
  }
  register TxDqDlyTg3_r7_p3 @'h3007c3 {
    field TxDqDlyTg3_r7_p3 @0 {
       bits 9;
       access rw;
       reset 9'h10;
    }
  }
  register TxDqDlyTg0_r8_p3 @'h3008c0 {
    field TxDqDlyTg0_r8_p3 @0 {
       bits 9;
       access rw;
       reset 9'h10;
    }
  }
  register TxDqDlyTg1_r8_p3 @'h3008c1 {
    field TxDqDlyTg1_r8_p3 @0 {
       bits 9;
       access rw;
       reset 9'h10;
    }
  }
  register TxDqDlyTg2_r8_p3 @'h3008c2 {
    field TxDqDlyTg2_r8_p3 @0 {
       bits 9;
       access rw;
       reset 9'h10;
    }
  }
  register TxDqDlyTg3_r8_p3 @'h3008c3 {
    field TxDqDlyTg3_r8_p3 @0 {
       bits 9;
       access rw;
       reset 9'h10;
    }
  }
}
block dwc_ddrphy_top_DWC_DDRPHYA_DBYTE7 {
  endian little;
  bytes 2;
  register DbyteMiscMode @'h0 {
    field Reserved @0 {
       bits 2;
    }
    field DByteDisable @2 {
       bits 1;
       access rw;
       reset 1'h0;
    }
  }
  register TsmByte0 @'h1 {
    field RFU_TsmByte0 @0 {
       bits 16;
       access rw;
       reset 16'h0;
    }
  }
  register TrainingParam @'h2 {
    field RFU_TrainingParam @0 {
       bits 16;
       access rw;
       reset 16'h0;
    }
  }
  register UseDqsEnReplica_p0 @'h3 {
    field UseDqsEnReplica_p0 @0 {
       bits 1;
       access rw;
       reset 1'h0;
    }
  }
  register RxTrainPatternEnable @'h10 {
    field RxTrainPatternEnable @0 {
       bits 1;
       access rw;
       reset 1'h0;
    }
  }
  register TsmByte1 @'h11 {
    field RFU_TsmByte1 @0 {
       bits 16;
       access rw;
       reset 16'h0;
    }
  }
  register TsmByte2 @'h12 {
    field RFU_TsmByte2 @0 {
       bits 16;
       access rw;
       reset 16'h0;
    }
  }
  register TsmByte3 @'h13 {
    field RFU_TsmByte3 @0 {
       bits 9;
       access rw;
       reset 9'h0;
    }
  }
  register TsmByte4 @'h14 {
    field RFU_TsmByte4 @0 {
       bits 4;
       access rw;
       reset 4'h0;
    }
  }
  register TestModeConfig @'h17 {
    field RFU_TestModeConfig @0 {
       bits 10;
       access rw;
       reset 10'h0;
    }
  }
  register TsmByte5 @'h18 {
    field RFU_TsmByte5 @0 {
       bits 16;
       access rw;
       reset 16'h0;
    }
  }
  register MtestMuxSel @'h1a {
    field MtestMuxSel @0 {
       bits 6;
       access rw;
       reset 6'h0;
    }
  }
  register DtsmTrainModeCtrl @'h1f {
    field RFU_DtsmTrainModeCtrl @0 {
       bits 4;
       access rw;
       reset 4'h0;
    }
  }
  register DFIMRL_p0 @'h20 {
    field DFIMRL_p0 @0 {
       bits 5;
       access rw;
       reset 5'h6;
    }
  }
  register AsyncDbyteMode @'h24 {
    field AsyncDbyteMode @0 {
       bits 9;
       access rw;
       reset 9'h0;
    }
  }
  register AsyncDbyteTxEn @'h26 {
    field AsyncDbyteTxEn @0 {
       bits 12;
       access rw;
       reset 12'h0;
    }
  }
  register AsyncDbyteTxData @'h28 {
    field AsyncDbyteTxData @0 {
       bits 12;
       access rw;
       reset 12'h0;
    }
  }
  register AsyncDbyteRxData @'h2a {
    field AsyncDbyteRxData @0 {
       bits 12;
       access ro;
       reset 12'h0;
    }
  }
  register VrefDAC1_r0 @'h30 {
    field VrefDAC1_r0 @0 {
       bits 7;
       access rw;
       reset 7'h0;
    }
  }
  register TrainingCntr_r0 @'h32 {
    field RFU_TrainingCntr_r0 @0 {
       bits 16;
       access rw;
       reset 16'h0;
    }
  }
  register VrefDAC0_r0 @'h40 {
    field VrefDAC0_r0 @0 {
       bits 7;
       access rw;
       reset 7'h0;
    }
  }
  register TxImpedanceCtrl0_b0_p0 @'h41 {
    field DrvStrenDqP @0 {
       bits 6;
       access rw;
       reset 6'h3f;
    }
    field DrvStrenDqN @6 {
       bits 6;
       access rw;
       reset 6'h3f;
    }
  }
  register DqDqsRcvCntrl_b0_p0 @'h43 {
    field SelAnalogVref @0 {
       bits 1;
       access rw;
       reset 1'h0;
    }
    field ExtVrefRange @1 {
       bits 1;
       access rw;
       reset 1'h0;
    }
    field DfeCtrl @2 {
       bits 2;
       access rw;
       reset 2'h0;
    }
    field MajorModeDbyte @4 {
       bits 3;
       access rw;
       reset 3'h3;
    }
    field GainCurrAdj @7 {
       bits 5;
       access rw;
       reset 5'hb;
    }
    field Reserved @12 {
       bits 4;
    }
  }
  register TxEqualizationMode_p0 @'h48 {
    field TxEqMode @0 {
       bits 2;
       access rw;
       reset 2'h0;
    }
  }
  register TxImpedanceCtrl1_b0_p0 @'h49 {
    field DrvStrenFSDqP @0 {
       bits 6;
       access rw;
       reset 6'h3f;
    }
    field DrvStrenFSDqN @6 {
       bits 6;
       access rw;
       reset 6'h3f;
    }
  }
  register DqDqsRcvCntrl1 @'h4a {
    field PowerDownRcvr @0 {
       bits 9;
       access rw;
       reset 9'h0;
    }
    field PowerDownRcvrDqs @9 {
       bits 1;
       access rw;
       reset 1'h0;
    }
    field RxPadStandbyEn @10 {
       bits 1;
       access rw;
       reset 1'h1;
    }
    field EnLPReqPDR @11 {
       bits 1;
       access rw;
       reset 1'h0;
    }
  }
  register TxImpedanceCtrl2_b0_p0 @'h4b {
    field DrvStrenEQHiDqP @0 {
       bits 6;
       access rw;
       reset 6'h0;
    }
    field DrvStrenEQLoDqN @6 {
       bits 6;
       access rw;
       reset 6'h0;
    }
  }
  register DqDqsRcvCntrl2_p0 @'h4c {
    field EnRxAgressivePDR @0 {
       bits 1;
       access rw;
       reset 1'h0;
    }
  }
  register TxOdtDrvStren_b0_p0 @'h4d {
    field ODTStrenP @0 {
       bits 6;
       access rw;
       reset 6'h0;
    }
    field ODTStrenN @6 {
       bits 6;
       access rw;
       reset 6'h0;
    }
  }
  register RxFifoCheckStatus @'h56 {
    field RxFifoLocErr @0 {
       bits 1;
       access ro;
       reset 1'h0;
    }
    field RxFifoLocUErr @1 {
       bits 1;
       access ro;
       reset 1'h0;
    }
  }
  register RxFifoCheckErrValues @'h57 {
    field RxFifoRdLocErrValue @0 {
       bits 4;
       access ro;
       reset 4'h0;
    }
    field RxFifoWrLocErrValue @4 {
       bits 4;
       access ro;
       reset 4'h0;
    }
    field RxFifoRdLocUErrValue @8 {
       bits 4;
       access ro;
       reset 4'h0;
    }
    field RxFifoWrLocUErrValue @12 {
       bits 4;
       access ro;
       reset 4'h0;
    }
  }
  register RxFifoInfo @'h58 {
    field RxFifoRdLoc @0 {
       bits 4;
       access ro;
       reset 4'h0;
    }
    field RxFifoWrLoc @4 {
       bits 4;
       access ro;
       reset 4'h0;
    }
    field RxFifoRdLocU @8 {
       bits 4;
       access ro;
       reset 4'h0;
    }
    field RxFifoWrLocU @12 {
       bits 4;
       access ro;
       reset 4'h0;
    }
  }
  register RxFifoVisibility @'h59 {
    field RxFifoRdPtr @0 {
       bits 3;
       access rw;
       reset 3'h0;
    }
    field RxFifoRdPtrOvr @3 {
       bits 1;
       access rw;
       reset 1'h0;
    }
    field RxFifoRdEn @4 {
       bits 1;
       access rw;
       reset 1'h0;
    }
  }
  register RxFifoContentsDQ3210 @'h5a {
    field RxFifoContentsDQ3210 @0 {
       bits 16;
       access ro;
       reset 16'h0;
    }
  }
  register RxFifoContentsDQ7654 @'h5b {
    field RxFifoContentsDQ7654 @0 {
       bits 16;
       access ro;
       reset 16'h0;
    }
  }
  register RxFifoContentsDBI @'h5c {
    field RxFifoContentsDBI @0 {
       bits 4;
       access ro;
       reset 4'h0;
    }
  }
  register TxSlewRate_b0_p0 @'h5f {
    field TxPreP @0 {
       bits 4;
       access rw;
       reset 4'hf;
    }
    field TxPreN @4 {
       bits 4;
       access rw;
       reset 4'hf;
    }
    field TxPreDrvMode @8 {
       bits 3;
       access rw;
       reset 3'h7;
    }
  }
  register TrainingIncDecDtsmEn_r0 @'h62 {
    field TrainingIncDecDtsmEn_r0 @0 {
       bits 9;
       access rw;
       reset 9'h0;
    }
  }
  register RxPBDlyTg0_r0 @'h68 {
    field RxPBDlyTg0_r0 @0 {
       bits 7;
       access rw;
       reset 7'h0;
    }
  }
  register RxPBDlyTg1_r0 @'h69 {
    field RxPBDlyTg1_r0 @0 {
       bits 7;
       access rw;
       reset 7'h0;
    }
  }
  register RxPBDlyTg2_r0 @'h6a {
    field RxPBDlyTg2_r0 @0 {
       bits 7;
       access rw;
       reset 7'h0;
    }
  }
  register RxPBDlyTg3_r0 @'h6b {
    field RxPBDlyTg3_r0 @0 {
       bits 7;
       access rw;
       reset 7'h0;
    }
  }
  register RxEnDlyTg0_u0_p0 @'h80 {
    field RxEnDlyTg0_u0_p0 @0 {
       bits 11;
       access rw;
       reset 11'h100;
    }
  }
  register RxEnDlyTg1_u0_p0 @'h81 {
    field RxEnDlyTg1_u0_p0 @0 {
       bits 11;
       access rw;
       reset 11'h100;
    }
  }
  register RxEnDlyTg2_u0_p0 @'h82 {
    field RxEnDlyTg2_u0_p0 @0 {
       bits 11;
       access rw;
       reset 11'h100;
    }
  }
  register RxEnDlyTg3_u0_p0 @'h83 {
    field RxEnDlyTg3_u0_p0 @0 {
       bits 11;
       access rw;
       reset 11'h100;
    }
  }
  register RxClkDlyTg0_u0_p0 @'h8c {
    field RxClkDlyTg0_u0_p0 @0 {
       bits 6;
       access rw;
       reset 6'h10;
    }
  }
  register RxClkDlyTg1_u0_p0 @'h8d {
    field RxClkDlyTg1_u0_p0 @0 {
       bits 6;
       access rw;
       reset 6'h10;
    }
  }
  register RxClkDlyTg2_u0_p0 @'h8e {
    field RxClkDlyTg2_u0_p0 @0 {
       bits 6;
       access rw;
       reset 6'h10;
    }
  }
  register RxClkDlyTg3_u0_p0 @'h8f {
    field RxClkDlyTg3_u0_p0 @0 {
       bits 6;
       access rw;
       reset 6'h10;
    }
  }
  register RxClkcDlyTg0_u0_p0 @'h90 {
    field RxClkcDlyTg0_u0_p0 @0 {
       bits 6;
       access rw;
       reset 6'h10;
    }
  }
  register RxClkcDlyTg1_u0_p0 @'h91 {
    field RxClkcDlyTg1_u0_p0 @0 {
       bits 6;
       access rw;
       reset 6'h10;
    }
  }
  register RxClkcDlyTg2_u0_p0 @'h92 {
    field RxClkcDlyTg2_u0_p0 @0 {
       bits 6;
       access rw;
       reset 6'h10;
    }
  }
  register RxClkcDlyTg3_u0_p0 @'h93 {
    field RxClkcDlyTg3_u0_p0 @0 {
       bits 6;
       access rw;
       reset 6'h10;
    }
  }
  register Dq0LnSel @'ha0 {
    field Dq0LnSel @0 {
       bits 3;
       access rw;
       reset 3'h0;
    }
  }
  register Dq1LnSel @'ha1 {
    field Dq1LnSel @0 {
       bits 3;
       access rw;
       reset 3'h1;
    }
  }
  register Dq2LnSel @'ha2 {
    field Dq2LnSel @0 {
       bits 3;
       access rw;
       reset 3'h2;
    }
  }
  register Dq3LnSel @'ha3 {
    field Dq3LnSel @0 {
       bits 3;
       access rw;
       reset 3'h3;
    }
  }
  register Dq4LnSel @'ha4 {
    field Dq4LnSel @0 {
       bits 3;
       access rw;
       reset 3'h4;
    }
  }
  register Dq5LnSel @'ha5 {
    field Dq5LnSel @0 {
       bits 3;
       access rw;
       reset 3'h5;
    }
  }
  register Dq6LnSel @'ha6 {
    field Dq6LnSel @0 {
       bits 3;
       access rw;
       reset 3'h6;
    }
  }
  register Dq7LnSel @'ha7 {
    field Dq7LnSel @0 {
       bits 3;
       access rw;
       reset 3'h7;
    }
  }
  register PptCtlStatic @'haa {
    field RFU_PptCtlStatic @0 {
       bits 12;
       access rw;
       reset 12'h0;
    }
  }
  register PptCtlDyn @'hab {
    field RFU_PptCtlDyn @0 {
       bits 2;
       access rw;
       reset 2'h0;
    }
  }
  register PptInfo @'hac {
    field PptInfo @0 {
       bits 16;
       access ro;
       reset 16'h0;
    }
  }
  register PptRxEnEvnt @'had {
    field RFU_PptRxEnEvnt @0 {
       bits 2;
       access rw;
       reset 2'h0;
    }
  }
  register PptDqsCntInvTrnTg0_p0 @'hae {
    field PptDqsCntInvTrnTg0_p0 @0 {
       bits 16;
       access rw;
       reset 16'h0;
    }
  }
  register PptDqsCntInvTrnTg1_p0 @'haf {
    field PptDqsCntInvTrnTg1_p0 @0 {
       bits 16;
       access rw;
       reset 16'h0;
    }
  }
  register DtsmBlankingCtrl @'hb1 {
    field RFU_DtsmBlankingCtrl @0 {
       bits 10;
       access rw;
       reset 10'h0;
    }
  }
  register Tsm0_i0 @'hb2 {
    field RFU_Tsm0_i0 @0 {
       bits 14;
       access rw;
       reset 14'h0;
    }
  }
  register Tsm1_i0 @'hb3 {
    field RFU_Tsm1_i0 @0 {
       bits 16;
       access ro;
       reset 16'h0;
    }
  }
  register Tsm2_i0 @'hb4 {
    field RFU_Tsm2_i0 @0 {
       bits 1;
       access rw;
       reset 1'h0;
    }
  }
  register Tsm3 @'hb5 {
    field RFU_Tsm3 @0 {
       bits 10;
       access rw;
       reset 10'h0;
    }
  }
  register TxChkDataSelects @'hb6 {
    field RFU_TxChkDataSelects @0 {
       bits 2;
       access rw;
       reset 2'h0;
    }
  }
  register DtsmUpThldXingInd @'hb7 {
    field DtsmUpThldXingInd @0 {
       bits 9;
       access ro;
       reset 9'h0;
    }
  }
  register DtsmLoThldXingInd @'hb8 {
    field DtsmLoThldXingInd @0 {
       bits 9;
       access ro;
       reset 9'h0;
    }
  }
  register DbyteAllDtsmCtrl0 @'hb9 {
    field RFU_DbyteAllDtsmCtrl0 @0 {
       bits 9;
       access rw;
       reset 9'h0;
    }
  }
  register DbyteAllDtsmCtrl1 @'hba {
    field RFU_DbyteAllDtsmCtrl1 @0 {
       bits 9;
       access rw;
       reset 9'h0;
    }
  }
  register DbyteAllDtsmCtrl2 @'hbb {
    field RFU_DbyteAllDtsmCtrl2 @0 {
       bits 9;
       access rw;
       reset 9'h0;
    }
  }
  register TxDqDlyTg0_r0_p0 @'hc0 {
    field TxDqDlyTg0_r0_p0 @0 {
       bits 9;
       access rw;
       reset 9'h10;
    }
  }
  register TxDqDlyTg1_r0_p0 @'hc1 {
    field TxDqDlyTg1_r0_p0 @0 {
       bits 9;
       access rw;
       reset 9'h10;
    }
  }
  register TxDqDlyTg2_r0_p0 @'hc2 {
    field TxDqDlyTg2_r0_p0 @0 {
       bits 9;
       access rw;
       reset 9'h10;
    }
  }
  register TxDqDlyTg3_r0_p0 @'hc3 {
    field TxDqDlyTg3_r0_p0 @0 {
       bits 9;
       access rw;
       reset 9'h10;
    }
  }
  register TxDqsDlyTg0_u0_p0 @'hd0 {
    field TxDqsDlyTg0_u0_p0 @0 {
       bits 10;
       access rw;
       reset 10'h100;
    }
  }
  register TxDqsDlyTg1_u0_p0 @'hd1 {
    field TxDqsDlyTg1_u0_p0 @0 {
       bits 10;
       access rw;
       reset 10'h100;
    }
  }
  register TxDqsDlyTg2_u0_p0 @'hd2 {
    field TxDqsDlyTg2_u0_p0 @0 {
       bits 10;
       access rw;
       reset 10'h100;
    }
  }
  register TxDqsDlyTg3_u0_p0 @'hd3 {
    field TxDqsDlyTg3_u0_p0 @0 {
       bits 10;
       access rw;
       reset 10'h100;
    }
  }
  register DxLcdlStatus @'he4 {
    field DxLcdlFineSnapVal @0 {
       bits 10;
       access ro;
       reset 10'h0;
    }
    field DxLcdlPhdSnapVal @10 {
       bits 1;
       access ro;
       reset 1'h0;
    }
    field DxLcdlStickyLock @11 {
       bits 1;
       access ro;
       reset 1'h0;
    }
    field DxLcdlStickyUnlock @12 {
       bits 1;
       access ro;
       reset 1'h0;
    }
    field DxLcdlLiveLock @13 {
       bits 1;
       access ro;
       reset 1'h0;
    }
  }
  register VrefDAC1_r1 @'h130 {
    field VrefDAC1_r1 @0 {
       bits 7;
       access rw;
       reset 7'h0;
    }
  }
  register TrainingCntr_r1 @'h132 {
    field RFU_TrainingCntr_r1 @0 {
       bits 16;
       access rw;
       reset 16'h0;
    }
  }
  register VrefDAC0_r1 @'h140 {
    field VrefDAC0_r1 @0 {
       bits 7;
       access rw;
       reset 7'h0;
    }
  }
  register TxImpedanceCtrl0_b1_p0 @'h141 {
    field DrvStrenDqP @0 {
       bits 6;
       access rw;
       reset 6'h3f;
    }
    field DrvStrenDqN @6 {
       bits 6;
       access rw;
       reset 6'h3f;
    }
  }
  register DqDqsRcvCntrl_b1_p0 @'h143 {
    field SelAnalogVref @0 {
       bits 1;
       access rw;
       reset 1'h0;
    }
    field ExtVrefRange @1 {
       bits 1;
       access rw;
       reset 1'h0;
    }
    field DfeCtrl @2 {
       bits 2;
       access rw;
       reset 2'h0;
    }
    field MajorModeDbyte @4 {
       bits 3;
       access rw;
       reset 3'h3;
    }
    field GainCurrAdj @7 {
       bits 5;
       access rw;
       reset 5'hb;
    }
    field Reserved @12 {
       bits 4;
    }
  }
  register TxImpedanceCtrl1_b1_p0 @'h149 {
    field DrvStrenFSDqP @0 {
       bits 6;
       access rw;
       reset 6'h3f;
    }
    field DrvStrenFSDqN @6 {
       bits 6;
       access rw;
       reset 6'h3f;
    }
  }
  register TxImpedanceCtrl2_b1_p0 @'h14b {
    field DrvStrenEQHiDqP @0 {
       bits 6;
       access rw;
       reset 6'h0;
    }
    field DrvStrenEQLoDqN @6 {
       bits 6;
       access rw;
       reset 6'h0;
    }
  }
  register TxOdtDrvStren_b1_p0 @'h14d {
    field ODTStrenP @0 {
       bits 6;
       access rw;
       reset 6'h0;
    }
    field ODTStrenN @6 {
       bits 6;
       access rw;
       reset 6'h0;
    }
  }
  register TxSlewRate_b1_p0 @'h15f {
    field TxPreP @0 {
       bits 4;
       access rw;
       reset 4'hf;
    }
    field TxPreN @4 {
       bits 4;
       access rw;
       reset 4'hf;
    }
    field TxPreDrvMode @8 {
       bits 3;
       access rw;
       reset 3'h7;
    }
  }
  register TrainingIncDecDtsmEn_r1 @'h162 {
    field TrainingIncDecDtsmEn_r1 @0 {
       bits 9;
       access rw;
       reset 9'h0;
    }
  }
  register RxPBDlyTg0_r1 @'h168 {
    field RxPBDlyTg0_r1 @0 {
       bits 7;
       access rw;
       reset 7'h0;
    }
  }
  register RxPBDlyTg1_r1 @'h169 {
    field RxPBDlyTg1_r1 @0 {
       bits 7;
       access rw;
       reset 7'h0;
    }
  }
  register RxPBDlyTg2_r1 @'h16a {
    field RxPBDlyTg2_r1 @0 {
       bits 7;
       access rw;
       reset 7'h0;
    }
  }
  register RxPBDlyTg3_r1 @'h16b {
    field RxPBDlyTg3_r1 @0 {
       bits 7;
       access rw;
       reset 7'h0;
    }
  }
  register RxEnDlyTg0_u1_p0 @'h180 {
    field RxEnDlyTg0_u1_p0 @0 {
       bits 11;
       access rw;
       reset 11'h100;
    }
  }
  register RxEnDlyTg1_u1_p0 @'h181 {
    field RxEnDlyTg1_u1_p0 @0 {
       bits 11;
       access rw;
       reset 11'h100;
    }
  }
  register RxEnDlyTg2_u1_p0 @'h182 {
    field RxEnDlyTg2_u1_p0 @0 {
       bits 11;
       access rw;
       reset 11'h100;
    }
  }
  register RxEnDlyTg3_u1_p0 @'h183 {
    field RxEnDlyTg3_u1_p0 @0 {
       bits 11;
       access rw;
       reset 11'h100;
    }
  }
  register RxClkDlyTg0_u1_p0 @'h18c {
    field RxClkDlyTg0_u1_p0 @0 {
       bits 6;
       access rw;
       reset 6'h10;
    }
  }
  register RxClkDlyTg1_u1_p0 @'h18d {
    field RxClkDlyTg1_u1_p0 @0 {
       bits 6;
       access rw;
       reset 6'h10;
    }
  }
  register RxClkDlyTg2_u1_p0 @'h18e {
    field RxClkDlyTg2_u1_p0 @0 {
       bits 6;
       access rw;
       reset 6'h10;
    }
  }
  register RxClkDlyTg3_u1_p0 @'h18f {
    field RxClkDlyTg3_u1_p0 @0 {
       bits 6;
       access rw;
       reset 6'h10;
    }
  }
  register RxClkcDlyTg0_u1_p0 @'h190 {
    field RxClkcDlyTg0_u1_p0 @0 {
       bits 6;
       access rw;
       reset 6'h10;
    }
  }
  register RxClkcDlyTg1_u1_p0 @'h191 {
    field RxClkcDlyTg1_u1_p0 @0 {
       bits 6;
       access rw;
       reset 6'h10;
    }
  }
  register RxClkcDlyTg2_u1_p0 @'h192 {
    field RxClkcDlyTg2_u1_p0 @0 {
       bits 6;
       access rw;
       reset 6'h10;
    }
  }
  register RxClkcDlyTg3_u1_p0 @'h193 {
    field RxClkcDlyTg3_u1_p0 @0 {
       bits 6;
       access rw;
       reset 6'h10;
    }
  }
  register Tsm0_i1 @'h1b2 {
    field RFU_Tsm0_i1 @0 {
       bits 14;
       access rw;
       reset 14'h0;
    }
  }
  register Tsm1_i1 @'h1b3 {
    field RFU_Tsm1_i1 @0 {
       bits 16;
       access ro;
       reset 16'h0;
    }
  }
  register Tsm2_i1 @'h1b4 {
    field RFU_Tsm2_i1 @0 {
       bits 1;
       access rw;
       reset 1'h0;
    }
  }
  register TxDqDlyTg0_r1_p0 @'h1c0 {
    field TxDqDlyTg0_r1_p0 @0 {
       bits 9;
       access rw;
       reset 9'h10;
    }
  }
  register TxDqDlyTg1_r1_p0 @'h1c1 {
    field TxDqDlyTg1_r1_p0 @0 {
       bits 9;
       access rw;
       reset 9'h10;
    }
  }
  register TxDqDlyTg2_r1_p0 @'h1c2 {
    field TxDqDlyTg2_r1_p0 @0 {
       bits 9;
       access rw;
       reset 9'h10;
    }
  }
  register TxDqDlyTg3_r1_p0 @'h1c3 {
    field TxDqDlyTg3_r1_p0 @0 {
       bits 9;
       access rw;
       reset 9'h10;
    }
  }
  register TxDqsDlyTg0_u1_p0 @'h1d0 {
    field TxDqsDlyTg0_u1_p0 @0 {
       bits 10;
       access rw;
       reset 10'h100;
    }
  }
  register TxDqsDlyTg1_u1_p0 @'h1d1 {
    field TxDqsDlyTg1_u1_p0 @0 {
       bits 10;
       access rw;
       reset 10'h100;
    }
  }
  register TxDqsDlyTg2_u1_p0 @'h1d2 {
    field TxDqsDlyTg2_u1_p0 @0 {
       bits 10;
       access rw;
       reset 10'h100;
    }
  }
  register TxDqsDlyTg3_u1_p0 @'h1d3 {
    field TxDqsDlyTg3_u1_p0 @0 {
       bits 10;
       access rw;
       reset 10'h100;
    }
  }
  register VrefDAC1_r2 @'h230 {
    field VrefDAC1_r2 @0 {
       bits 7;
       access rw;
       reset 7'h0;
    }
  }
  register TrainingCntr_r2 @'h232 {
    field RFU_TrainingCntr_r2 @0 {
       bits 16;
       access rw;
       reset 16'h0;
    }
  }
  register VrefDAC0_r2 @'h240 {
    field VrefDAC0_r2 @0 {
       bits 7;
       access rw;
       reset 7'h0;
    }
  }
  register TrainingIncDecDtsmEn_r2 @'h262 {
    field TrainingIncDecDtsmEn_r2 @0 {
       bits 9;
       access rw;
       reset 9'h0;
    }
  }
  register RxPBDlyTg0_r2 @'h268 {
    field RxPBDlyTg0_r2 @0 {
       bits 7;
       access rw;
       reset 7'h0;
    }
  }
  register RxPBDlyTg1_r2 @'h269 {
    field RxPBDlyTg1_r2 @0 {
       bits 7;
       access rw;
       reset 7'h0;
    }
  }
  register RxPBDlyTg2_r2 @'h26a {
    field RxPBDlyTg2_r2 @0 {
       bits 7;
       access rw;
       reset 7'h0;
    }
  }
  register RxPBDlyTg3_r2 @'h26b {
    field RxPBDlyTg3_r2 @0 {
       bits 7;
       access rw;
       reset 7'h0;
    }
  }
  register Tsm0_i2 @'h2b2 {
    field RFU_Tsm0_i2 @0 {
       bits 14;
       access rw;
       reset 14'h0;
    }
  }
  register Tsm1_i2 @'h2b3 {
    field RFU_Tsm1_i2 @0 {
       bits 16;
       access ro;
       reset 16'h0;
    }
  }
  register Tsm2_i2 @'h2b4 {
    field RFU_Tsm2_i2 @0 {
       bits 1;
       access rw;
       reset 1'h0;
    }
  }
  register TxDqDlyTg0_r2_p0 @'h2c0 {
    field TxDqDlyTg0_r2_p0 @0 {
       bits 9;
       access rw;
       reset 9'h10;
    }
  }
  register TxDqDlyTg1_r2_p0 @'h2c1 {
    field TxDqDlyTg1_r2_p0 @0 {
       bits 9;
       access rw;
       reset 9'h10;
    }
  }
  register TxDqDlyTg2_r2_p0 @'h2c2 {
    field TxDqDlyTg2_r2_p0 @0 {
       bits 9;
       access rw;
       reset 9'h10;
    }
  }
  register TxDqDlyTg3_r2_p0 @'h2c3 {
    field TxDqDlyTg3_r2_p0 @0 {
       bits 9;
       access rw;
       reset 9'h10;
    }
  }
  register VrefDAC1_r3 @'h330 {
    field VrefDAC1_r3 @0 {
       bits 7;
       access rw;
       reset 7'h0;
    }
  }
  register TrainingCntr_r3 @'h332 {
    field RFU_TrainingCntr_r3 @0 {
       bits 16;
       access rw;
       reset 16'h0;
    }
  }
  register VrefDAC0_r3 @'h340 {
    field VrefDAC0_r3 @0 {
       bits 7;
       access rw;
       reset 7'h0;
    }
  }
  register TrainingIncDecDtsmEn_r3 @'h362 {
    field TrainingIncDecDtsmEn_r3 @0 {
       bits 9;
       access rw;
       reset 9'h0;
    }
  }
  register RxPBDlyTg0_r3 @'h368 {
    field RxPBDlyTg0_r3 @0 {
       bits 7;
       access rw;
       reset 7'h0;
    }
  }
  register RxPBDlyTg1_r3 @'h369 {
    field RxPBDlyTg1_r3 @0 {
       bits 7;
       access rw;
       reset 7'h0;
    }
  }
  register RxPBDlyTg2_r3 @'h36a {
    field RxPBDlyTg2_r3 @0 {
       bits 7;
       access rw;
       reset 7'h0;
    }
  }
  register RxPBDlyTg3_r3 @'h36b {
    field RxPBDlyTg3_r3 @0 {
       bits 7;
       access rw;
       reset 7'h0;
    }
  }
  register Tsm0_i3 @'h3b2 {
    field RFU_Tsm0_i3 @0 {
       bits 14;
       access rw;
       reset 14'h0;
    }
  }
  register Tsm1_i3 @'h3b3 {
    field RFU_Tsm1_i3 @0 {
       bits 16;
       access ro;
       reset 16'h0;
    }
  }
  register Tsm2_i3 @'h3b4 {
    field RFU_Tsm2_i3 @0 {
       bits 1;
       access rw;
       reset 1'h0;
    }
  }
  register TxDqDlyTg0_r3_p0 @'h3c0 {
    field TxDqDlyTg0_r3_p0 @0 {
       bits 9;
       access rw;
       reset 9'h10;
    }
  }
  register TxDqDlyTg1_r3_p0 @'h3c1 {
    field TxDqDlyTg1_r3_p0 @0 {
       bits 9;
       access rw;
       reset 9'h10;
    }
  }
  register TxDqDlyTg2_r3_p0 @'h3c2 {
    field TxDqDlyTg2_r3_p0 @0 {
       bits 9;
       access rw;
       reset 9'h10;
    }
  }
  register TxDqDlyTg3_r3_p0 @'h3c3 {
    field TxDqDlyTg3_r3_p0 @0 {
       bits 9;
       access rw;
       reset 9'h10;
    }
  }
  register VrefDAC1_r4 @'h430 {
    field VrefDAC1_r4 @0 {
       bits 7;
       access rw;
       reset 7'h0;
    }
  }
  register TrainingCntr_r4 @'h432 {
    field RFU_TrainingCntr_r4 @0 {
       bits 16;
       access rw;
       reset 16'h0;
    }
  }
  register VrefDAC0_r4 @'h440 {
    field VrefDAC0_r4 @0 {
       bits 7;
       access rw;
       reset 7'h0;
    }
  }
  register TrainingIncDecDtsmEn_r4 @'h462 {
    field TrainingIncDecDtsmEn_r4 @0 {
       bits 9;
       access rw;
       reset 9'h0;
    }
  }
  register RxPBDlyTg0_r4 @'h468 {
    field RxPBDlyTg0_r4 @0 {
       bits 7;
       access rw;
       reset 7'h0;
    }
  }
  register RxPBDlyTg1_r4 @'h469 {
    field RxPBDlyTg1_r4 @0 {
       bits 7;
       access rw;
       reset 7'h0;
    }
  }
  register RxPBDlyTg2_r4 @'h46a {
    field RxPBDlyTg2_r4 @0 {
       bits 7;
       access rw;
       reset 7'h0;
    }
  }
  register RxPBDlyTg3_r4 @'h46b {
    field RxPBDlyTg3_r4 @0 {
       bits 7;
       access rw;
       reset 7'h0;
    }
  }
  register Tsm0_i4 @'h4b2 {
    field RFU_Tsm0_i4 @0 {
       bits 14;
       access rw;
       reset 14'h0;
    }
  }
  register Tsm1_i4 @'h4b3 {
    field RFU_Tsm1_i4 @0 {
       bits 16;
       access ro;
       reset 16'h0;
    }
  }
  register Tsm2_i4 @'h4b4 {
    field RFU_Tsm2_i4 @0 {
       bits 1;
       access rw;
       reset 1'h0;
    }
  }
  register TxDqDlyTg0_r4_p0 @'h4c0 {
    field TxDqDlyTg0_r4_p0 @0 {
       bits 9;
       access rw;
       reset 9'h10;
    }
  }
  register TxDqDlyTg1_r4_p0 @'h4c1 {
    field TxDqDlyTg1_r4_p0 @0 {
       bits 9;
       access rw;
       reset 9'h10;
    }
  }
  register TxDqDlyTg2_r4_p0 @'h4c2 {
    field TxDqDlyTg2_r4_p0 @0 {
       bits 9;
       access rw;
       reset 9'h10;
    }
  }
  register TxDqDlyTg3_r4_p0 @'h4c3 {
    field TxDqDlyTg3_r4_p0 @0 {
       bits 9;
       access rw;
       reset 9'h10;
    }
  }
  register VrefDAC1_r5 @'h530 {
    field VrefDAC1_r5 @0 {
       bits 7;
       access rw;
       reset 7'h0;
    }
  }
  register TrainingCntr_r5 @'h532 {
    field RFU_TrainingCntr_r5 @0 {
       bits 16;
       access rw;
       reset 16'h0;
    }
  }
  register VrefDAC0_r5 @'h540 {
    field VrefDAC0_r5 @0 {
       bits 7;
       access rw;
       reset 7'h0;
    }
  }
  register TrainingIncDecDtsmEn_r5 @'h562 {
    field TrainingIncDecDtsmEn_r5 @0 {
       bits 9;
       access rw;
       reset 9'h0;
    }
  }
  register RxPBDlyTg0_r5 @'h568 {
    field RxPBDlyTg0_r5 @0 {
       bits 7;
       access rw;
       reset 7'h0;
    }
  }
  register RxPBDlyTg1_r5 @'h569 {
    field RxPBDlyTg1_r5 @0 {
       bits 7;
       access rw;
       reset 7'h0;
    }
  }
  register RxPBDlyTg2_r5 @'h56a {
    field RxPBDlyTg2_r5 @0 {
       bits 7;
       access rw;
       reset 7'h0;
    }
  }
  register RxPBDlyTg3_r5 @'h56b {
    field RxPBDlyTg3_r5 @0 {
       bits 7;
       access rw;
       reset 7'h0;
    }
  }
  register Tsm0_i5 @'h5b2 {
    field RFU_Tsm0_i5 @0 {
       bits 14;
       access rw;
       reset 14'h0;
    }
  }
  register Tsm1_i5 @'h5b3 {
    field RFU_Tsm1_i5 @0 {
       bits 16;
       access ro;
       reset 16'h0;
    }
  }
  register Tsm2_i5 @'h5b4 {
    field RFU_Tsm2_i5 @0 {
       bits 1;
       access rw;
       reset 1'h0;
    }
  }
  register TxDqDlyTg0_r5_p0 @'h5c0 {
    field TxDqDlyTg0_r5_p0 @0 {
       bits 9;
       access rw;
       reset 9'h10;
    }
  }
  register TxDqDlyTg1_r5_p0 @'h5c1 {
    field TxDqDlyTg1_r5_p0 @0 {
       bits 9;
       access rw;
       reset 9'h10;
    }
  }
  register TxDqDlyTg2_r5_p0 @'h5c2 {
    field TxDqDlyTg2_r5_p0 @0 {
       bits 9;
       access rw;
       reset 9'h10;
    }
  }
  register TxDqDlyTg3_r5_p0 @'h5c3 {
    field TxDqDlyTg3_r5_p0 @0 {
       bits 9;
       access rw;
       reset 9'h10;
    }
  }
  register VrefDAC1_r6 @'h630 {
    field VrefDAC1_r6 @0 {
       bits 7;
       access rw;
       reset 7'h0;
    }
  }
  register TrainingCntr_r6 @'h632 {
    field RFU_TrainingCntr_r6 @0 {
       bits 16;
       access rw;
       reset 16'h0;
    }
  }
  register VrefDAC0_r6 @'h640 {
    field VrefDAC0_r6 @0 {
       bits 7;
       access rw;
       reset 7'h0;
    }
  }
  register TrainingIncDecDtsmEn_r6 @'h662 {
    field TrainingIncDecDtsmEn_r6 @0 {
       bits 9;
       access rw;
       reset 9'h0;
    }
  }
  register RxPBDlyTg0_r6 @'h668 {
    field RxPBDlyTg0_r6 @0 {
       bits 7;
       access rw;
       reset 7'h0;
    }
  }
  register RxPBDlyTg1_r6 @'h669 {
    field RxPBDlyTg1_r6 @0 {
       bits 7;
       access rw;
       reset 7'h0;
    }
  }
  register RxPBDlyTg2_r6 @'h66a {
    field RxPBDlyTg2_r6 @0 {
       bits 7;
       access rw;
       reset 7'h0;
    }
  }
  register RxPBDlyTg3_r6 @'h66b {
    field RxPBDlyTg3_r6 @0 {
       bits 7;
       access rw;
       reset 7'h0;
    }
  }
  register Tsm0_i6 @'h6b2 {
    field RFU_Tsm0_i6 @0 {
       bits 14;
       access rw;
       reset 14'h0;
    }
  }
  register Tsm1_i6 @'h6b3 {
    field RFU_Tsm1_i6 @0 {
       bits 16;
       access ro;
       reset 16'h0;
    }
  }
  register Tsm2_i6 @'h6b4 {
    field RFU_Tsm2_i6 @0 {
       bits 1;
       access rw;
       reset 1'h0;
    }
  }
  register TxDqDlyTg0_r6_p0 @'h6c0 {
    field TxDqDlyTg0_r6_p0 @0 {
       bits 9;
       access rw;
       reset 9'h10;
    }
  }
  register TxDqDlyTg1_r6_p0 @'h6c1 {
    field TxDqDlyTg1_r6_p0 @0 {
       bits 9;
       access rw;
       reset 9'h10;
    }
  }
  register TxDqDlyTg2_r6_p0 @'h6c2 {
    field TxDqDlyTg2_r6_p0 @0 {
       bits 9;
       access rw;
       reset 9'h10;
    }
  }
  register TxDqDlyTg3_r6_p0 @'h6c3 {
    field TxDqDlyTg3_r6_p0 @0 {
       bits 9;
       access rw;
       reset 9'h10;
    }
  }
  register VrefDAC1_r7 @'h730 {
    field VrefDAC1_r7 @0 {
       bits 7;
       access rw;
       reset 7'h0;
    }
  }
  register TrainingCntr_r7 @'h732 {
    field RFU_TrainingCntr_r7 @0 {
       bits 16;
       access rw;
       reset 16'h0;
    }
  }
  register VrefDAC0_r7 @'h740 {
    field VrefDAC0_r7 @0 {
       bits 7;
       access rw;
       reset 7'h0;
    }
  }
  register TrainingIncDecDtsmEn_r7 @'h762 {
    field TrainingIncDecDtsmEn_r7 @0 {
       bits 9;
       access rw;
       reset 9'h0;
    }
  }
  register RxPBDlyTg0_r7 @'h768 {
    field RxPBDlyTg0_r7 @0 {
       bits 7;
       access rw;
       reset 7'h0;
    }
  }
  register RxPBDlyTg1_r7 @'h769 {
    field RxPBDlyTg1_r7 @0 {
       bits 7;
       access rw;
       reset 7'h0;
    }
  }
  register RxPBDlyTg2_r7 @'h76a {
    field RxPBDlyTg2_r7 @0 {
       bits 7;
       access rw;
       reset 7'h0;
    }
  }
  register RxPBDlyTg3_r7 @'h76b {
    field RxPBDlyTg3_r7 @0 {
       bits 7;
       access rw;
       reset 7'h0;
    }
  }
  register Tsm0_i7 @'h7b2 {
    field RFU_Tsm0_i7 @0 {
       bits 14;
       access rw;
       reset 14'h0;
    }
  }
  register Tsm1_i7 @'h7b3 {
    field RFU_Tsm1_i7 @0 {
       bits 16;
       access ro;
       reset 16'h0;
    }
  }
  register Tsm2_i7 @'h7b4 {
    field RFU_Tsm2_i7 @0 {
       bits 1;
       access rw;
       reset 1'h0;
    }
  }
  register TxDqDlyTg0_r7_p0 @'h7c0 {
    field TxDqDlyTg0_r7_p0 @0 {
       bits 9;
       access rw;
       reset 9'h10;
    }
  }
  register TxDqDlyTg1_r7_p0 @'h7c1 {
    field TxDqDlyTg1_r7_p0 @0 {
       bits 9;
       access rw;
       reset 9'h10;
    }
  }
  register TxDqDlyTg2_r7_p0 @'h7c2 {
    field TxDqDlyTg2_r7_p0 @0 {
       bits 9;
       access rw;
       reset 9'h10;
    }
  }
  register TxDqDlyTg3_r7_p0 @'h7c3 {
    field TxDqDlyTg3_r7_p0 @0 {
       bits 9;
       access rw;
       reset 9'h10;
    }
  }
  register VrefDAC1_r8 @'h830 {
    field VrefDAC1_r8 @0 {
       bits 7;
       access rw;
       reset 7'h0;
    }
  }
  register TrainingCntr_r8 @'h832 {
    field RFU_TrainingCntr_r8 @0 {
       bits 16;
       access rw;
       reset 16'h0;
    }
  }
  register VrefDAC0_r8 @'h840 {
    field VrefDAC0_r8 @0 {
       bits 7;
       access rw;
       reset 7'h0;
    }
  }
  register TrainingIncDecDtsmEn_r8 @'h862 {
    field TrainingIncDecDtsmEn_r8 @0 {
       bits 9;
       access rw;
       reset 9'h0;
    }
  }
  register RxPBDlyTg0_r8 @'h868 {
    field RxPBDlyTg0_r8 @0 {
       bits 7;
       access rw;
       reset 7'h0;
    }
  }
  register RxPBDlyTg1_r8 @'h869 {
    field RxPBDlyTg1_r8 @0 {
       bits 7;
       access rw;
       reset 7'h0;
    }
  }
  register RxPBDlyTg2_r8 @'h86a {
    field RxPBDlyTg2_r8 @0 {
       bits 7;
       access rw;
       reset 7'h0;
    }
  }
  register RxPBDlyTg3_r8 @'h86b {
    field RxPBDlyTg3_r8 @0 {
       bits 7;
       access rw;
       reset 7'h0;
    }
  }
  register Tsm0_i8 @'h8b2 {
    field RFU_Tsm0_i8 @0 {
       bits 14;
       access rw;
       reset 14'h0;
    }
  }
  register Tsm1_i8 @'h8b3 {
    field RFU_Tsm1_i8 @0 {
       bits 16;
       access ro;
       reset 16'h0;
    }
  }
  register Tsm2_i8 @'h8b4 {
    field RFU_Tsm2_i8 @0 {
       bits 1;
       access rw;
       reset 1'h0;
    }
  }
  register TxDqDlyTg0_r8_p0 @'h8c0 {
    field TxDqDlyTg0_r8_p0 @0 {
       bits 9;
       access rw;
       reset 9'h10;
    }
  }
  register TxDqDlyTg1_r8_p0 @'h8c1 {
    field TxDqDlyTg1_r8_p0 @0 {
       bits 9;
       access rw;
       reset 9'h10;
    }
  }
  register TxDqDlyTg2_r8_p0 @'h8c2 {
    field TxDqDlyTg2_r8_p0 @0 {
       bits 9;
       access rw;
       reset 9'h10;
    }
  }
  register TxDqDlyTg3_r8_p0 @'h8c3 {
    field TxDqDlyTg3_r8_p0 @0 {
       bits 9;
       access rw;
       reset 9'h10;
    }
  }
  register UseDqsEnReplica_p1 @'h100003 {
    field UseDqsEnReplica_p1 @0 {
       bits 1;
       access rw;
       reset 1'h0;
    }
  }
  register DFIMRL_p1 @'h100020 {
    field DFIMRL_p1 @0 {
       bits 5;
       access rw;
       reset 5'h6;
    }
  }
  register TxImpedanceCtrl0_b0_p1 @'h100041 {
    field DrvStrenDqP @0 {
       bits 6;
       access rw;
       reset 6'h3f;
    }
    field DrvStrenDqN @6 {
       bits 6;
       access rw;
       reset 6'h3f;
    }
  }
  register DqDqsRcvCntrl_b0_p1 @'h100043 {
    field SelAnalogVref @0 {
       bits 1;
       access rw;
       reset 1'h0;
    }
    field ExtVrefRange @1 {
       bits 1;
       access rw;
       reset 1'h0;
    }
    field DfeCtrl @2 {
       bits 2;
       access rw;
       reset 2'h0;
    }
    field MajorModeDbyte @4 {
       bits 3;
       access rw;
       reset 3'h3;
    }
    field GainCurrAdj @7 {
       bits 5;
       access rw;
       reset 5'hb;
    }
    field Reserved @12 {
       bits 4;
    }
  }
  register TxEqualizationMode_p1 @'h100048 {
    field TxEqMode @0 {
       bits 2;
       access rw;
       reset 2'h0;
    }
  }
  register TxImpedanceCtrl1_b0_p1 @'h100049 {
    field DrvStrenFSDqP @0 {
       bits 6;
       access rw;
       reset 6'h3f;
    }
    field DrvStrenFSDqN @6 {
       bits 6;
       access rw;
       reset 6'h3f;
    }
  }
  register TxImpedanceCtrl2_b0_p1 @'h10004b {
    field DrvStrenEQHiDqP @0 {
       bits 6;
       access rw;
       reset 6'h0;
    }
    field DrvStrenEQLoDqN @6 {
       bits 6;
       access rw;
       reset 6'h0;
    }
  }
  register DqDqsRcvCntrl2_p1 @'h10004c {
    field EnRxAgressivePDR @0 {
       bits 1;
       access rw;
       reset 1'h0;
    }
  }
  register TxOdtDrvStren_b0_p1 @'h10004d {
    field ODTStrenP @0 {
       bits 6;
       access rw;
       reset 6'h0;
    }
    field ODTStrenN @6 {
       bits 6;
       access rw;
       reset 6'h0;
    }
  }
  register TxSlewRate_b0_p1 @'h10005f {
    field TxPreP @0 {
       bits 4;
       access rw;
       reset 4'hf;
    }
    field TxPreN @4 {
       bits 4;
       access rw;
       reset 4'hf;
    }
    field TxPreDrvMode @8 {
       bits 3;
       access rw;
       reset 3'h7;
    }
  }
  register RxEnDlyTg0_u0_p1 @'h100080 {
    field RxEnDlyTg0_u0_p1 @0 {
       bits 11;
       access rw;
       reset 11'h100;
    }
  }
  register RxEnDlyTg1_u0_p1 @'h100081 {
    field RxEnDlyTg1_u0_p1 @0 {
       bits 11;
       access rw;
       reset 11'h100;
    }
  }
  register RxEnDlyTg2_u0_p1 @'h100082 {
    field RxEnDlyTg2_u0_p1 @0 {
       bits 11;
       access rw;
       reset 11'h100;
    }
  }
  register RxEnDlyTg3_u0_p1 @'h100083 {
    field RxEnDlyTg3_u0_p1 @0 {
       bits 11;
       access rw;
       reset 11'h100;
    }
  }
  register RxClkDlyTg0_u0_p1 @'h10008c {
    field RxClkDlyTg0_u0_p1 @0 {
       bits 6;
       access rw;
       reset 6'h10;
    }
  }
  register RxClkDlyTg1_u0_p1 @'h10008d {
    field RxClkDlyTg1_u0_p1 @0 {
       bits 6;
       access rw;
       reset 6'h10;
    }
  }
  register RxClkDlyTg2_u0_p1 @'h10008e {
    field RxClkDlyTg2_u0_p1 @0 {
       bits 6;
       access rw;
       reset 6'h10;
    }
  }
  register RxClkDlyTg3_u0_p1 @'h10008f {
    field RxClkDlyTg3_u0_p1 @0 {
       bits 6;
       access rw;
       reset 6'h10;
    }
  }
  register RxClkcDlyTg0_u0_p1 @'h100090 {
    field RxClkcDlyTg0_u0_p1 @0 {
       bits 6;
       access rw;
       reset 6'h10;
    }
  }
  register RxClkcDlyTg1_u0_p1 @'h100091 {
    field RxClkcDlyTg1_u0_p1 @0 {
       bits 6;
       access rw;
       reset 6'h10;
    }
  }
  register RxClkcDlyTg2_u0_p1 @'h100092 {
    field RxClkcDlyTg2_u0_p1 @0 {
       bits 6;
       access rw;
       reset 6'h10;
    }
  }
  register RxClkcDlyTg3_u0_p1 @'h100093 {
    field RxClkcDlyTg3_u0_p1 @0 {
       bits 6;
       access rw;
       reset 6'h10;
    }
  }
  register PptDqsCntInvTrnTg0_p1 @'h1000ae {
    field PptDqsCntInvTrnTg0_p1 @0 {
       bits 16;
       access rw;
       reset 16'h0;
    }
  }
  register PptDqsCntInvTrnTg1_p1 @'h1000af {
    field PptDqsCntInvTrnTg1_p1 @0 {
       bits 16;
       access rw;
       reset 16'h0;
    }
  }
  register TxDqDlyTg0_r0_p1 @'h1000c0 {
    field TxDqDlyTg0_r0_p1 @0 {
       bits 9;
       access rw;
       reset 9'h10;
    }
  }
  register TxDqDlyTg1_r0_p1 @'h1000c1 {
    field TxDqDlyTg1_r0_p1 @0 {
       bits 9;
       access rw;
       reset 9'h10;
    }
  }
  register TxDqDlyTg2_r0_p1 @'h1000c2 {
    field TxDqDlyTg2_r0_p1 @0 {
       bits 9;
       access rw;
       reset 9'h10;
    }
  }
  register TxDqDlyTg3_r0_p1 @'h1000c3 {
    field TxDqDlyTg3_r0_p1 @0 {
       bits 9;
       access rw;
       reset 9'h10;
    }
  }
  register TxDqsDlyTg0_u0_p1 @'h1000d0 {
    field TxDqsDlyTg0_u0_p1 @0 {
       bits 10;
       access rw;
       reset 10'h100;
    }
  }
  register TxDqsDlyTg1_u0_p1 @'h1000d1 {
    field TxDqsDlyTg1_u0_p1 @0 {
       bits 10;
       access rw;
       reset 10'h100;
    }
  }
  register TxDqsDlyTg2_u0_p1 @'h1000d2 {
    field TxDqsDlyTg2_u0_p1 @0 {
       bits 10;
       access rw;
       reset 10'h100;
    }
  }
  register TxDqsDlyTg3_u0_p1 @'h1000d3 {
    field TxDqsDlyTg3_u0_p1 @0 {
       bits 10;
       access rw;
       reset 10'h100;
    }
  }
  register TxImpedanceCtrl0_b1_p1 @'h100141 {
    field DrvStrenDqP @0 {
       bits 6;
       access rw;
       reset 6'h3f;
    }
    field DrvStrenDqN @6 {
       bits 6;
       access rw;
       reset 6'h3f;
    }
  }
  register DqDqsRcvCntrl_b1_p1 @'h100143 {
    field SelAnalogVref @0 {
       bits 1;
       access rw;
       reset 1'h0;
    }
    field ExtVrefRange @1 {
       bits 1;
       access rw;
       reset 1'h0;
    }
    field DfeCtrl @2 {
       bits 2;
       access rw;
       reset 2'h0;
    }
    field MajorModeDbyte @4 {
       bits 3;
       access rw;
       reset 3'h3;
    }
    field GainCurrAdj @7 {
       bits 5;
       access rw;
       reset 5'hb;
    }
    field Reserved @12 {
       bits 4;
    }
  }
  register TxImpedanceCtrl1_b1_p1 @'h100149 {
    field DrvStrenFSDqP @0 {
       bits 6;
       access rw;
       reset 6'h3f;
    }
    field DrvStrenFSDqN @6 {
       bits 6;
       access rw;
       reset 6'h3f;
    }
  }
  register TxImpedanceCtrl2_b1_p1 @'h10014b {
    field DrvStrenEQHiDqP @0 {
       bits 6;
       access rw;
       reset 6'h0;
    }
    field DrvStrenEQLoDqN @6 {
       bits 6;
       access rw;
       reset 6'h0;
    }
  }
  register TxOdtDrvStren_b1_p1 @'h10014d {
    field ODTStrenP @0 {
       bits 6;
       access rw;
       reset 6'h0;
    }
    field ODTStrenN @6 {
       bits 6;
       access rw;
       reset 6'h0;
    }
  }
  register TxSlewRate_b1_p1 @'h10015f {
    field TxPreP @0 {
       bits 4;
       access rw;
       reset 4'hf;
    }
    field TxPreN @4 {
       bits 4;
       access rw;
       reset 4'hf;
    }
    field TxPreDrvMode @8 {
       bits 3;
       access rw;
       reset 3'h7;
    }
  }
  register RxEnDlyTg0_u1_p1 @'h100180 {
    field RxEnDlyTg0_u1_p1 @0 {
       bits 11;
       access rw;
       reset 11'h100;
    }
  }
  register RxEnDlyTg1_u1_p1 @'h100181 {
    field RxEnDlyTg1_u1_p1 @0 {
       bits 11;
       access rw;
       reset 11'h100;
    }
  }
  register RxEnDlyTg2_u1_p1 @'h100182 {
    field RxEnDlyTg2_u1_p1 @0 {
       bits 11;
       access rw;
       reset 11'h100;
    }
  }
  register RxEnDlyTg3_u1_p1 @'h100183 {
    field RxEnDlyTg3_u1_p1 @0 {
       bits 11;
       access rw;
       reset 11'h100;
    }
  }
  register RxClkDlyTg0_u1_p1 @'h10018c {
    field RxClkDlyTg0_u1_p1 @0 {
       bits 6;
       access rw;
       reset 6'h10;
    }
  }
  register RxClkDlyTg1_u1_p1 @'h10018d {
    field RxClkDlyTg1_u1_p1 @0 {
       bits 6;
       access rw;
       reset 6'h10;
    }
  }
  register RxClkDlyTg2_u1_p1 @'h10018e {
    field RxClkDlyTg2_u1_p1 @0 {
       bits 6;
       access rw;
       reset 6'h10;
    }
  }
  register RxClkDlyTg3_u1_p1 @'h10018f {
    field RxClkDlyTg3_u1_p1 @0 {
       bits 6;
       access rw;
       reset 6'h10;
    }
  }
  register RxClkcDlyTg0_u1_p1 @'h100190 {
    field RxClkcDlyTg0_u1_p1 @0 {
       bits 6;
       access rw;
       reset 6'h10;
    }
  }
  register RxClkcDlyTg1_u1_p1 @'h100191 {
    field RxClkcDlyTg1_u1_p1 @0 {
       bits 6;
       access rw;
       reset 6'h10;
    }
  }
  register RxClkcDlyTg2_u1_p1 @'h100192 {
    field RxClkcDlyTg2_u1_p1 @0 {
       bits 6;
       access rw;
       reset 6'h10;
    }
  }
  register RxClkcDlyTg3_u1_p1 @'h100193 {
    field RxClkcDlyTg3_u1_p1 @0 {
       bits 6;
       access rw;
       reset 6'h10;
    }
  }
  register TxDqDlyTg0_r1_p1 @'h1001c0 {
    field TxDqDlyTg0_r1_p1 @0 {
       bits 9;
       access rw;
       reset 9'h10;
    }
  }
  register TxDqDlyTg1_r1_p1 @'h1001c1 {
    field TxDqDlyTg1_r1_p1 @0 {
       bits 9;
       access rw;
       reset 9'h10;
    }
  }
  register TxDqDlyTg2_r1_p1 @'h1001c2 {
    field TxDqDlyTg2_r1_p1 @0 {
       bits 9;
       access rw;
       reset 9'h10;
    }
  }
  register TxDqDlyTg3_r1_p1 @'h1001c3 {
    field TxDqDlyTg3_r1_p1 @0 {
       bits 9;
       access rw;
       reset 9'h10;
    }
  }
  register TxDqsDlyTg0_u1_p1 @'h1001d0 {
    field TxDqsDlyTg0_u1_p1 @0 {
       bits 10;
       access rw;
       reset 10'h100;
    }
  }
  register TxDqsDlyTg1_u1_p1 @'h1001d1 {
    field TxDqsDlyTg1_u1_p1 @0 {
       bits 10;
       access rw;
       reset 10'h100;
    }
  }
  register TxDqsDlyTg2_u1_p1 @'h1001d2 {
    field TxDqsDlyTg2_u1_p1 @0 {
       bits 10;
       access rw;
       reset 10'h100;
    }
  }
  register TxDqsDlyTg3_u1_p1 @'h1001d3 {
    field TxDqsDlyTg3_u1_p1 @0 {
       bits 10;
       access rw;
       reset 10'h100;
    }
  }
  register TxDqDlyTg0_r2_p1 @'h1002c0 {
    field TxDqDlyTg0_r2_p1 @0 {
       bits 9;
       access rw;
       reset 9'h10;
    }
  }
  register TxDqDlyTg1_r2_p1 @'h1002c1 {
    field TxDqDlyTg1_r2_p1 @0 {
       bits 9;
       access rw;
       reset 9'h10;
    }
  }
  register TxDqDlyTg2_r2_p1 @'h1002c2 {
    field TxDqDlyTg2_r2_p1 @0 {
       bits 9;
       access rw;
       reset 9'h10;
    }
  }
  register TxDqDlyTg3_r2_p1 @'h1002c3 {
    field TxDqDlyTg3_r2_p1 @0 {
       bits 9;
       access rw;
       reset 9'h10;
    }
  }
  register TxDqDlyTg0_r3_p1 @'h1003c0 {
    field TxDqDlyTg0_r3_p1 @0 {
       bits 9;
       access rw;
       reset 9'h10;
    }
  }
  register TxDqDlyTg1_r3_p1 @'h1003c1 {
    field TxDqDlyTg1_r3_p1 @0 {
       bits 9;
       access rw;
       reset 9'h10;
    }
  }
  register TxDqDlyTg2_r3_p1 @'h1003c2 {
    field TxDqDlyTg2_r3_p1 @0 {
       bits 9;
       access rw;
       reset 9'h10;
    }
  }
  register TxDqDlyTg3_r3_p1 @'h1003c3 {
    field TxDqDlyTg3_r3_p1 @0 {
       bits 9;
       access rw;
       reset 9'h10;
    }
  }
  register TxDqDlyTg0_r4_p1 @'h1004c0 {
    field TxDqDlyTg0_r4_p1 @0 {
       bits 9;
       access rw;
       reset 9'h10;
    }
  }
  register TxDqDlyTg1_r4_p1 @'h1004c1 {
    field TxDqDlyTg1_r4_p1 @0 {
       bits 9;
       access rw;
       reset 9'h10;
    }
  }
  register TxDqDlyTg2_r4_p1 @'h1004c2 {
    field TxDqDlyTg2_r4_p1 @0 {
       bits 9;
       access rw;
       reset 9'h10;
    }
  }
  register TxDqDlyTg3_r4_p1 @'h1004c3 {
    field TxDqDlyTg3_r4_p1 @0 {
       bits 9;
       access rw;
       reset 9'h10;
    }
  }
  register TxDqDlyTg0_r5_p1 @'h1005c0 {
    field TxDqDlyTg0_r5_p1 @0 {
       bits 9;
       access rw;
       reset 9'h10;
    }
  }
  register TxDqDlyTg1_r5_p1 @'h1005c1 {
    field TxDqDlyTg1_r5_p1 @0 {
       bits 9;
       access rw;
       reset 9'h10;
    }
  }
  register TxDqDlyTg2_r5_p1 @'h1005c2 {
    field TxDqDlyTg2_r5_p1 @0 {
       bits 9;
       access rw;
       reset 9'h10;
    }
  }
  register TxDqDlyTg3_r5_p1 @'h1005c3 {
    field TxDqDlyTg3_r5_p1 @0 {
       bits 9;
       access rw;
       reset 9'h10;
    }
  }
  register TxDqDlyTg0_r6_p1 @'h1006c0 {
    field TxDqDlyTg0_r6_p1 @0 {
       bits 9;
       access rw;
       reset 9'h10;
    }
  }
  register TxDqDlyTg1_r6_p1 @'h1006c1 {
    field TxDqDlyTg1_r6_p1 @0 {
       bits 9;
       access rw;
       reset 9'h10;
    }
  }
  register TxDqDlyTg2_r6_p1 @'h1006c2 {
    field TxDqDlyTg2_r6_p1 @0 {
       bits 9;
       access rw;
       reset 9'h10;
    }
  }
  register TxDqDlyTg3_r6_p1 @'h1006c3 {
    field TxDqDlyTg3_r6_p1 @0 {
       bits 9;
       access rw;
       reset 9'h10;
    }
  }
  register TxDqDlyTg0_r7_p1 @'h1007c0 {
    field TxDqDlyTg0_r7_p1 @0 {
       bits 9;
       access rw;
       reset 9'h10;
    }
  }
  register TxDqDlyTg1_r7_p1 @'h1007c1 {
    field TxDqDlyTg1_r7_p1 @0 {
       bits 9;
       access rw;
       reset 9'h10;
    }
  }
  register TxDqDlyTg2_r7_p1 @'h1007c2 {
    field TxDqDlyTg2_r7_p1 @0 {
       bits 9;
       access rw;
       reset 9'h10;
    }
  }
  register TxDqDlyTg3_r7_p1 @'h1007c3 {
    field TxDqDlyTg3_r7_p1 @0 {
       bits 9;
       access rw;
       reset 9'h10;
    }
  }
  register TxDqDlyTg0_r8_p1 @'h1008c0 {
    field TxDqDlyTg0_r8_p1 @0 {
       bits 9;
       access rw;
       reset 9'h10;
    }
  }
  register TxDqDlyTg1_r8_p1 @'h1008c1 {
    field TxDqDlyTg1_r8_p1 @0 {
       bits 9;
       access rw;
       reset 9'h10;
    }
  }
  register TxDqDlyTg2_r8_p1 @'h1008c2 {
    field TxDqDlyTg2_r8_p1 @0 {
       bits 9;
       access rw;
       reset 9'h10;
    }
  }
  register TxDqDlyTg3_r8_p1 @'h1008c3 {
    field TxDqDlyTg3_r8_p1 @0 {
       bits 9;
       access rw;
       reset 9'h10;
    }
  }
  register UseDqsEnReplica_p2 @'h200003 {
    field UseDqsEnReplica_p2 @0 {
       bits 1;
       access rw;
       reset 1'h0;
    }
  }
  register DFIMRL_p2 @'h200020 {
    field DFIMRL_p2 @0 {
       bits 5;
       access rw;
       reset 5'h6;
    }
  }
  register TxImpedanceCtrl0_b0_p2 @'h200041 {
    field DrvStrenDqP @0 {
       bits 6;
       access rw;
       reset 6'h3f;
    }
    field DrvStrenDqN @6 {
       bits 6;
       access rw;
       reset 6'h3f;
    }
  }
  register DqDqsRcvCntrl_b0_p2 @'h200043 {
    field SelAnalogVref @0 {
       bits 1;
       access rw;
       reset 1'h0;
    }
    field ExtVrefRange @1 {
       bits 1;
       access rw;
       reset 1'h0;
    }
    field DfeCtrl @2 {
       bits 2;
       access rw;
       reset 2'h0;
    }
    field MajorModeDbyte @4 {
       bits 3;
       access rw;
       reset 3'h3;
    }
    field GainCurrAdj @7 {
       bits 5;
       access rw;
       reset 5'hb;
    }
    field Reserved @12 {
       bits 4;
    }
  }
  register TxEqualizationMode_p2 @'h200048 {
    field TxEqMode @0 {
       bits 2;
       access rw;
       reset 2'h0;
    }
  }
  register TxImpedanceCtrl1_b0_p2 @'h200049 {
    field DrvStrenFSDqP @0 {
       bits 6;
       access rw;
       reset 6'h3f;
    }
    field DrvStrenFSDqN @6 {
       bits 6;
       access rw;
       reset 6'h3f;
    }
  }
  register TxImpedanceCtrl2_b0_p2 @'h20004b {
    field DrvStrenEQHiDqP @0 {
       bits 6;
       access rw;
       reset 6'h0;
    }
    field DrvStrenEQLoDqN @6 {
       bits 6;
       access rw;
       reset 6'h0;
    }
  }
  register DqDqsRcvCntrl2_p2 @'h20004c {
    field EnRxAgressivePDR @0 {
       bits 1;
       access rw;
       reset 1'h0;
    }
  }
  register TxOdtDrvStren_b0_p2 @'h20004d {
    field ODTStrenP @0 {
       bits 6;
       access rw;
       reset 6'h0;
    }
    field ODTStrenN @6 {
       bits 6;
       access rw;
       reset 6'h0;
    }
  }
  register TxSlewRate_b0_p2 @'h20005f {
    field TxPreP @0 {
       bits 4;
       access rw;
       reset 4'hf;
    }
    field TxPreN @4 {
       bits 4;
       access rw;
       reset 4'hf;
    }
    field TxPreDrvMode @8 {
       bits 3;
       access rw;
       reset 3'h7;
    }
  }
  register RxEnDlyTg0_u0_p2 @'h200080 {
    field RxEnDlyTg0_u0_p2 @0 {
       bits 11;
       access rw;
       reset 11'h100;
    }
  }
  register RxEnDlyTg1_u0_p2 @'h200081 {
    field RxEnDlyTg1_u0_p2 @0 {
       bits 11;
       access rw;
       reset 11'h100;
    }
  }
  register RxEnDlyTg2_u0_p2 @'h200082 {
    field RxEnDlyTg2_u0_p2 @0 {
       bits 11;
       access rw;
       reset 11'h100;
    }
  }
  register RxEnDlyTg3_u0_p2 @'h200083 {
    field RxEnDlyTg3_u0_p2 @0 {
       bits 11;
       access rw;
       reset 11'h100;
    }
  }
  register RxClkDlyTg0_u0_p2 @'h20008c {
    field RxClkDlyTg0_u0_p2 @0 {
       bits 6;
       access rw;
       reset 6'h10;
    }
  }
  register RxClkDlyTg1_u0_p2 @'h20008d {
    field RxClkDlyTg1_u0_p2 @0 {
       bits 6;
       access rw;
       reset 6'h10;
    }
  }
  register RxClkDlyTg2_u0_p2 @'h20008e {
    field RxClkDlyTg2_u0_p2 @0 {
       bits 6;
       access rw;
       reset 6'h10;
    }
  }
  register RxClkDlyTg3_u0_p2 @'h20008f {
    field RxClkDlyTg3_u0_p2 @0 {
       bits 6;
       access rw;
       reset 6'h10;
    }
  }
  register RxClkcDlyTg0_u0_p2 @'h200090 {
    field RxClkcDlyTg0_u0_p2 @0 {
       bits 6;
       access rw;
       reset 6'h10;
    }
  }
  register RxClkcDlyTg1_u0_p2 @'h200091 {
    field RxClkcDlyTg1_u0_p2 @0 {
       bits 6;
       access rw;
       reset 6'h10;
    }
  }
  register RxClkcDlyTg2_u0_p2 @'h200092 {
    field RxClkcDlyTg2_u0_p2 @0 {
       bits 6;
       access rw;
       reset 6'h10;
    }
  }
  register RxClkcDlyTg3_u0_p2 @'h200093 {
    field RxClkcDlyTg3_u0_p2 @0 {
       bits 6;
       access rw;
       reset 6'h10;
    }
  }
  register PptDqsCntInvTrnTg0_p2 @'h2000ae {
    field PptDqsCntInvTrnTg0_p2 @0 {
       bits 16;
       access rw;
       reset 16'h0;
    }
  }
  register PptDqsCntInvTrnTg1_p2 @'h2000af {
    field PptDqsCntInvTrnTg1_p2 @0 {
       bits 16;
       access rw;
       reset 16'h0;
    }
  }
  register TxDqDlyTg0_r0_p2 @'h2000c0 {
    field TxDqDlyTg0_r0_p2 @0 {
       bits 9;
       access rw;
       reset 9'h10;
    }
  }
  register TxDqDlyTg1_r0_p2 @'h2000c1 {
    field TxDqDlyTg1_r0_p2 @0 {
       bits 9;
       access rw;
       reset 9'h10;
    }
  }
  register TxDqDlyTg2_r0_p2 @'h2000c2 {
    field TxDqDlyTg2_r0_p2 @0 {
       bits 9;
       access rw;
       reset 9'h10;
    }
  }
  register TxDqDlyTg3_r0_p2 @'h2000c3 {
    field TxDqDlyTg3_r0_p2 @0 {
       bits 9;
       access rw;
       reset 9'h10;
    }
  }
  register TxDqsDlyTg0_u0_p2 @'h2000d0 {
    field TxDqsDlyTg0_u0_p2 @0 {
       bits 10;
       access rw;
       reset 10'h100;
    }
  }
  register TxDqsDlyTg1_u0_p2 @'h2000d1 {
    field TxDqsDlyTg1_u0_p2 @0 {
       bits 10;
       access rw;
       reset 10'h100;
    }
  }
  register TxDqsDlyTg2_u0_p2 @'h2000d2 {
    field TxDqsDlyTg2_u0_p2 @0 {
       bits 10;
       access rw;
       reset 10'h100;
    }
  }
  register TxDqsDlyTg3_u0_p2 @'h2000d3 {
    field TxDqsDlyTg3_u0_p2 @0 {
       bits 10;
       access rw;
       reset 10'h100;
    }
  }
  register TxImpedanceCtrl0_b1_p2 @'h200141 {
    field DrvStrenDqP @0 {
       bits 6;
       access rw;
       reset 6'h3f;
    }
    field DrvStrenDqN @6 {
       bits 6;
       access rw;
       reset 6'h3f;
    }
  }
  register DqDqsRcvCntrl_b1_p2 @'h200143 {
    field SelAnalogVref @0 {
       bits 1;
       access rw;
       reset 1'h0;
    }
    field ExtVrefRange @1 {
       bits 1;
       access rw;
       reset 1'h0;
    }
    field DfeCtrl @2 {
       bits 2;
       access rw;
       reset 2'h0;
    }
    field MajorModeDbyte @4 {
       bits 3;
       access rw;
       reset 3'h3;
    }
    field GainCurrAdj @7 {
       bits 5;
       access rw;
       reset 5'hb;
    }
    field Reserved @12 {
       bits 4;
    }
  }
  register TxImpedanceCtrl1_b1_p2 @'h200149 {
    field DrvStrenFSDqP @0 {
       bits 6;
       access rw;
       reset 6'h3f;
    }
    field DrvStrenFSDqN @6 {
       bits 6;
       access rw;
       reset 6'h3f;
    }
  }
  register TxImpedanceCtrl2_b1_p2 @'h20014b {
    field DrvStrenEQHiDqP @0 {
       bits 6;
       access rw;
       reset 6'h0;
    }
    field DrvStrenEQLoDqN @6 {
       bits 6;
       access rw;
       reset 6'h0;
    }
  }
  register TxOdtDrvStren_b1_p2 @'h20014d {
    field ODTStrenP @0 {
       bits 6;
       access rw;
       reset 6'h0;
    }
    field ODTStrenN @6 {
       bits 6;
       access rw;
       reset 6'h0;
    }
  }
  register TxSlewRate_b1_p2 @'h20015f {
    field TxPreP @0 {
       bits 4;
       access rw;
       reset 4'hf;
    }
    field TxPreN @4 {
       bits 4;
       access rw;
       reset 4'hf;
    }
    field TxPreDrvMode @8 {
       bits 3;
       access rw;
       reset 3'h7;
    }
  }
  register RxEnDlyTg0_u1_p2 @'h200180 {
    field RxEnDlyTg0_u1_p2 @0 {
       bits 11;
       access rw;
       reset 11'h100;
    }
  }
  register RxEnDlyTg1_u1_p2 @'h200181 {
    field RxEnDlyTg1_u1_p2 @0 {
       bits 11;
       access rw;
       reset 11'h100;
    }
  }
  register RxEnDlyTg2_u1_p2 @'h200182 {
    field RxEnDlyTg2_u1_p2 @0 {
       bits 11;
       access rw;
       reset 11'h100;
    }
  }
  register RxEnDlyTg3_u1_p2 @'h200183 {
    field RxEnDlyTg3_u1_p2 @0 {
       bits 11;
       access rw;
       reset 11'h100;
    }
  }
  register RxClkDlyTg0_u1_p2 @'h20018c {
    field RxClkDlyTg0_u1_p2 @0 {
       bits 6;
       access rw;
       reset 6'h10;
    }
  }
  register RxClkDlyTg1_u1_p2 @'h20018d {
    field RxClkDlyTg1_u1_p2 @0 {
       bits 6;
       access rw;
       reset 6'h10;
    }
  }
  register RxClkDlyTg2_u1_p2 @'h20018e {
    field RxClkDlyTg2_u1_p2 @0 {
       bits 6;
       access rw;
       reset 6'h10;
    }
  }
  register RxClkDlyTg3_u1_p2 @'h20018f {
    field RxClkDlyTg3_u1_p2 @0 {
       bits 6;
       access rw;
       reset 6'h10;
    }
  }
  register RxClkcDlyTg0_u1_p2 @'h200190 {
    field RxClkcDlyTg0_u1_p2 @0 {
       bits 6;
       access rw;
       reset 6'h10;
    }
  }
  register RxClkcDlyTg1_u1_p2 @'h200191 {
    field RxClkcDlyTg1_u1_p2 @0 {
       bits 6;
       access rw;
       reset 6'h10;
    }
  }
  register RxClkcDlyTg2_u1_p2 @'h200192 {
    field RxClkcDlyTg2_u1_p2 @0 {
       bits 6;
       access rw;
       reset 6'h10;
    }
  }
  register RxClkcDlyTg3_u1_p2 @'h200193 {
    field RxClkcDlyTg3_u1_p2 @0 {
       bits 6;
       access rw;
       reset 6'h10;
    }
  }
  register TxDqDlyTg0_r1_p2 @'h2001c0 {
    field TxDqDlyTg0_r1_p2 @0 {
       bits 9;
       access rw;
       reset 9'h10;
    }
  }
  register TxDqDlyTg1_r1_p2 @'h2001c1 {
    field TxDqDlyTg1_r1_p2 @0 {
       bits 9;
       access rw;
       reset 9'h10;
    }
  }
  register TxDqDlyTg2_r1_p2 @'h2001c2 {
    field TxDqDlyTg2_r1_p2 @0 {
       bits 9;
       access rw;
       reset 9'h10;
    }
  }
  register TxDqDlyTg3_r1_p2 @'h2001c3 {
    field TxDqDlyTg3_r1_p2 @0 {
       bits 9;
       access rw;
       reset 9'h10;
    }
  }
  register TxDqsDlyTg0_u1_p2 @'h2001d0 {
    field TxDqsDlyTg0_u1_p2 @0 {
       bits 10;
       access rw;
       reset 10'h100;
    }
  }
  register TxDqsDlyTg1_u1_p2 @'h2001d1 {
    field TxDqsDlyTg1_u1_p2 @0 {
       bits 10;
       access rw;
       reset 10'h100;
    }
  }
  register TxDqsDlyTg2_u1_p2 @'h2001d2 {
    field TxDqsDlyTg2_u1_p2 @0 {
       bits 10;
       access rw;
       reset 10'h100;
    }
  }
  register TxDqsDlyTg3_u1_p2 @'h2001d3 {
    field TxDqsDlyTg3_u1_p2 @0 {
       bits 10;
       access rw;
       reset 10'h100;
    }
  }
  register TxDqDlyTg0_r2_p2 @'h2002c0 {
    field TxDqDlyTg0_r2_p2 @0 {
       bits 9;
       access rw;
       reset 9'h10;
    }
  }
  register TxDqDlyTg1_r2_p2 @'h2002c1 {
    field TxDqDlyTg1_r2_p2 @0 {
       bits 9;
       access rw;
       reset 9'h10;
    }
  }
  register TxDqDlyTg2_r2_p2 @'h2002c2 {
    field TxDqDlyTg2_r2_p2 @0 {
       bits 9;
       access rw;
       reset 9'h10;
    }
  }
  register TxDqDlyTg3_r2_p2 @'h2002c3 {
    field TxDqDlyTg3_r2_p2 @0 {
       bits 9;
       access rw;
       reset 9'h10;
    }
  }
  register TxDqDlyTg0_r3_p2 @'h2003c0 {
    field TxDqDlyTg0_r3_p2 @0 {
       bits 9;
       access rw;
       reset 9'h10;
    }
  }
  register TxDqDlyTg1_r3_p2 @'h2003c1 {
    field TxDqDlyTg1_r3_p2 @0 {
       bits 9;
       access rw;
       reset 9'h10;
    }
  }
  register TxDqDlyTg2_r3_p2 @'h2003c2 {
    field TxDqDlyTg2_r3_p2 @0 {
       bits 9;
       access rw;
       reset 9'h10;
    }
  }
  register TxDqDlyTg3_r3_p2 @'h2003c3 {
    field TxDqDlyTg3_r3_p2 @0 {
       bits 9;
       access rw;
       reset 9'h10;
    }
  }
  register TxDqDlyTg0_r4_p2 @'h2004c0 {
    field TxDqDlyTg0_r4_p2 @0 {
       bits 9;
       access rw;
       reset 9'h10;
    }
  }
  register TxDqDlyTg1_r4_p2 @'h2004c1 {
    field TxDqDlyTg1_r4_p2 @0 {
       bits 9;
       access rw;
       reset 9'h10;
    }
  }
  register TxDqDlyTg2_r4_p2 @'h2004c2 {
    field TxDqDlyTg2_r4_p2 @0 {
       bits 9;
       access rw;
       reset 9'h10;
    }
  }
  register TxDqDlyTg3_r4_p2 @'h2004c3 {
    field TxDqDlyTg3_r4_p2 @0 {
       bits 9;
       access rw;
       reset 9'h10;
    }
  }
  register TxDqDlyTg0_r5_p2 @'h2005c0 {
    field TxDqDlyTg0_r5_p2 @0 {
       bits 9;
       access rw;
       reset 9'h10;
    }
  }
  register TxDqDlyTg1_r5_p2 @'h2005c1 {
    field TxDqDlyTg1_r5_p2 @0 {
       bits 9;
       access rw;
       reset 9'h10;
    }
  }
  register TxDqDlyTg2_r5_p2 @'h2005c2 {
    field TxDqDlyTg2_r5_p2 @0 {
       bits 9;
       access rw;
       reset 9'h10;
    }
  }
  register TxDqDlyTg3_r5_p2 @'h2005c3 {
    field TxDqDlyTg3_r5_p2 @0 {
       bits 9;
       access rw;
       reset 9'h10;
    }
  }
  register TxDqDlyTg0_r6_p2 @'h2006c0 {
    field TxDqDlyTg0_r6_p2 @0 {
       bits 9;
       access rw;
       reset 9'h10;
    }
  }
  register TxDqDlyTg1_r6_p2 @'h2006c1 {
    field TxDqDlyTg1_r6_p2 @0 {
       bits 9;
       access rw;
       reset 9'h10;
    }
  }
  register TxDqDlyTg2_r6_p2 @'h2006c2 {
    field TxDqDlyTg2_r6_p2 @0 {
       bits 9;
       access rw;
       reset 9'h10;
    }
  }
  register TxDqDlyTg3_r6_p2 @'h2006c3 {
    field TxDqDlyTg3_r6_p2 @0 {
       bits 9;
       access rw;
       reset 9'h10;
    }
  }
  register TxDqDlyTg0_r7_p2 @'h2007c0 {
    field TxDqDlyTg0_r7_p2 @0 {
       bits 9;
       access rw;
       reset 9'h10;
    }
  }
  register TxDqDlyTg1_r7_p2 @'h2007c1 {
    field TxDqDlyTg1_r7_p2 @0 {
       bits 9;
       access rw;
       reset 9'h10;
    }
  }
  register TxDqDlyTg2_r7_p2 @'h2007c2 {
    field TxDqDlyTg2_r7_p2 @0 {
       bits 9;
       access rw;
       reset 9'h10;
    }
  }
  register TxDqDlyTg3_r7_p2 @'h2007c3 {
    field TxDqDlyTg3_r7_p2 @0 {
       bits 9;
       access rw;
       reset 9'h10;
    }
  }
  register TxDqDlyTg0_r8_p2 @'h2008c0 {
    field TxDqDlyTg0_r8_p2 @0 {
       bits 9;
       access rw;
       reset 9'h10;
    }
  }
  register TxDqDlyTg1_r8_p2 @'h2008c1 {
    field TxDqDlyTg1_r8_p2 @0 {
       bits 9;
       access rw;
       reset 9'h10;
    }
  }
  register TxDqDlyTg2_r8_p2 @'h2008c2 {
    field TxDqDlyTg2_r8_p2 @0 {
       bits 9;
       access rw;
       reset 9'h10;
    }
  }
  register TxDqDlyTg3_r8_p2 @'h2008c3 {
    field TxDqDlyTg3_r8_p2 @0 {
       bits 9;
       access rw;
       reset 9'h10;
    }
  }
  register UseDqsEnReplica_p3 @'h300003 {
    field UseDqsEnReplica_p3 @0 {
       bits 1;
       access rw;
       reset 1'h0;
    }
  }
  register DFIMRL_p3 @'h300020 {
    field DFIMRL_p3 @0 {
       bits 5;
       access rw;
       reset 5'h6;
    }
  }
  register TxImpedanceCtrl0_b0_p3 @'h300041 {
    field DrvStrenDqP @0 {
       bits 6;
       access rw;
       reset 6'h3f;
    }
    field DrvStrenDqN @6 {
       bits 6;
       access rw;
       reset 6'h3f;
    }
  }
  register DqDqsRcvCntrl_b0_p3 @'h300043 {
    field SelAnalogVref @0 {
       bits 1;
       access rw;
       reset 1'h0;
    }
    field ExtVrefRange @1 {
       bits 1;
       access rw;
       reset 1'h0;
    }
    field DfeCtrl @2 {
       bits 2;
       access rw;
       reset 2'h0;
    }
    field MajorModeDbyte @4 {
       bits 3;
       access rw;
       reset 3'h3;
    }
    field GainCurrAdj @7 {
       bits 5;
       access rw;
       reset 5'hb;
    }
    field Reserved @12 {
       bits 4;
    }
  }
  register TxEqualizationMode_p3 @'h300048 {
    field TxEqMode @0 {
       bits 2;
       access rw;
       reset 2'h0;
    }
  }
  register TxImpedanceCtrl1_b0_p3 @'h300049 {
    field DrvStrenFSDqP @0 {
       bits 6;
       access rw;
       reset 6'h3f;
    }
    field DrvStrenFSDqN @6 {
       bits 6;
       access rw;
       reset 6'h3f;
    }
  }
  register TxImpedanceCtrl2_b0_p3 @'h30004b {
    field DrvStrenEQHiDqP @0 {
       bits 6;
       access rw;
       reset 6'h0;
    }
    field DrvStrenEQLoDqN @6 {
       bits 6;
       access rw;
       reset 6'h0;
    }
  }
  register DqDqsRcvCntrl2_p3 @'h30004c {
    field EnRxAgressivePDR @0 {
       bits 1;
       access rw;
       reset 1'h0;
    }
  }
  register TxOdtDrvStren_b0_p3 @'h30004d {
    field ODTStrenP @0 {
       bits 6;
       access rw;
       reset 6'h0;
    }
    field ODTStrenN @6 {
       bits 6;
       access rw;
       reset 6'h0;
    }
  }
  register TxSlewRate_b0_p3 @'h30005f {
    field TxPreP @0 {
       bits 4;
       access rw;
       reset 4'hf;
    }
    field TxPreN @4 {
       bits 4;
       access rw;
       reset 4'hf;
    }
    field TxPreDrvMode @8 {
       bits 3;
       access rw;
       reset 3'h7;
    }
  }
  register RxEnDlyTg0_u0_p3 @'h300080 {
    field RxEnDlyTg0_u0_p3 @0 {
       bits 11;
       access rw;
       reset 11'h100;
    }
  }
  register RxEnDlyTg1_u0_p3 @'h300081 {
    field RxEnDlyTg1_u0_p3 @0 {
       bits 11;
       access rw;
       reset 11'h100;
    }
  }
  register RxEnDlyTg2_u0_p3 @'h300082 {
    field RxEnDlyTg2_u0_p3 @0 {
       bits 11;
       access rw;
       reset 11'h100;
    }
  }
  register RxEnDlyTg3_u0_p3 @'h300083 {
    field RxEnDlyTg3_u0_p3 @0 {
       bits 11;
       access rw;
       reset 11'h100;
    }
  }
  register RxClkDlyTg0_u0_p3 @'h30008c {
    field RxClkDlyTg0_u0_p3 @0 {
       bits 6;
       access rw;
       reset 6'h10;
    }
  }
  register RxClkDlyTg1_u0_p3 @'h30008d {
    field RxClkDlyTg1_u0_p3 @0 {
       bits 6;
       access rw;
       reset 6'h10;
    }
  }
  register RxClkDlyTg2_u0_p3 @'h30008e {
    field RxClkDlyTg2_u0_p3 @0 {
       bits 6;
       access rw;
       reset 6'h10;
    }
  }
  register RxClkDlyTg3_u0_p3 @'h30008f {
    field RxClkDlyTg3_u0_p3 @0 {
       bits 6;
       access rw;
       reset 6'h10;
    }
  }
  register RxClkcDlyTg0_u0_p3 @'h300090 {
    field RxClkcDlyTg0_u0_p3 @0 {
       bits 6;
       access rw;
       reset 6'h10;
    }
  }
  register RxClkcDlyTg1_u0_p3 @'h300091 {
    field RxClkcDlyTg1_u0_p3 @0 {
       bits 6;
       access rw;
       reset 6'h10;
    }
  }
  register RxClkcDlyTg2_u0_p3 @'h300092 {
    field RxClkcDlyTg2_u0_p3 @0 {
       bits 6;
       access rw;
       reset 6'h10;
    }
  }
  register RxClkcDlyTg3_u0_p3 @'h300093 {
    field RxClkcDlyTg3_u0_p3 @0 {
       bits 6;
       access rw;
       reset 6'h10;
    }
  }
  register PptDqsCntInvTrnTg0_p3 @'h3000ae {
    field PptDqsCntInvTrnTg0_p3 @0 {
       bits 16;
       access rw;
       reset 16'h0;
    }
  }
  register PptDqsCntInvTrnTg1_p3 @'h3000af {
    field PptDqsCntInvTrnTg1_p3 @0 {
       bits 16;
       access rw;
       reset 16'h0;
    }
  }
  register TxDqDlyTg0_r0_p3 @'h3000c0 {
    field TxDqDlyTg0_r0_p3 @0 {
       bits 9;
       access rw;
       reset 9'h10;
    }
  }
  register TxDqDlyTg1_r0_p3 @'h3000c1 {
    field TxDqDlyTg1_r0_p3 @0 {
       bits 9;
       access rw;
       reset 9'h10;
    }
  }
  register TxDqDlyTg2_r0_p3 @'h3000c2 {
    field TxDqDlyTg2_r0_p3 @0 {
       bits 9;
       access rw;
       reset 9'h10;
    }
  }
  register TxDqDlyTg3_r0_p3 @'h3000c3 {
    field TxDqDlyTg3_r0_p3 @0 {
       bits 9;
       access rw;
       reset 9'h10;
    }
  }
  register TxDqsDlyTg0_u0_p3 @'h3000d0 {
    field TxDqsDlyTg0_u0_p3 @0 {
       bits 10;
       access rw;
       reset 10'h100;
    }
  }
  register TxDqsDlyTg1_u0_p3 @'h3000d1 {
    field TxDqsDlyTg1_u0_p3 @0 {
       bits 10;
       access rw;
       reset 10'h100;
    }
  }
  register TxDqsDlyTg2_u0_p3 @'h3000d2 {
    field TxDqsDlyTg2_u0_p3 @0 {
       bits 10;
       access rw;
       reset 10'h100;
    }
  }
  register TxDqsDlyTg3_u0_p3 @'h3000d3 {
    field TxDqsDlyTg3_u0_p3 @0 {
       bits 10;
       access rw;
       reset 10'h100;
    }
  }
  register TxImpedanceCtrl0_b1_p3 @'h300141 {
    field DrvStrenDqP @0 {
       bits 6;
       access rw;
       reset 6'h3f;
    }
    field DrvStrenDqN @6 {
       bits 6;
       access rw;
       reset 6'h3f;
    }
  }
  register DqDqsRcvCntrl_b1_p3 @'h300143 {
    field SelAnalogVref @0 {
       bits 1;
       access rw;
       reset 1'h0;
    }
    field ExtVrefRange @1 {
       bits 1;
       access rw;
       reset 1'h0;
    }
    field DfeCtrl @2 {
       bits 2;
       access rw;
       reset 2'h0;
    }
    field MajorModeDbyte @4 {
       bits 3;
       access rw;
       reset 3'h3;
    }
    field GainCurrAdj @7 {
       bits 5;
       access rw;
       reset 5'hb;
    }
    field Reserved @12 {
       bits 4;
    }
  }
  register TxImpedanceCtrl1_b1_p3 @'h300149 {
    field DrvStrenFSDqP @0 {
       bits 6;
       access rw;
       reset 6'h3f;
    }
    field DrvStrenFSDqN @6 {
       bits 6;
       access rw;
       reset 6'h3f;
    }
  }
  register TxImpedanceCtrl2_b1_p3 @'h30014b {
    field DrvStrenEQHiDqP @0 {
       bits 6;
       access rw;
       reset 6'h0;
    }
    field DrvStrenEQLoDqN @6 {
       bits 6;
       access rw;
       reset 6'h0;
    }
  }
  register TxOdtDrvStren_b1_p3 @'h30014d {
    field ODTStrenP @0 {
       bits 6;
       access rw;
       reset 6'h0;
    }
    field ODTStrenN @6 {
       bits 6;
       access rw;
       reset 6'h0;
    }
  }
  register TxSlewRate_b1_p3 @'h30015f {
    field TxPreP @0 {
       bits 4;
       access rw;
       reset 4'hf;
    }
    field TxPreN @4 {
       bits 4;
       access rw;
       reset 4'hf;
    }
    field TxPreDrvMode @8 {
       bits 3;
       access rw;
       reset 3'h7;
    }
  }
  register RxEnDlyTg0_u1_p3 @'h300180 {
    field RxEnDlyTg0_u1_p3 @0 {
       bits 11;
       access rw;
       reset 11'h100;
    }
  }
  register RxEnDlyTg1_u1_p3 @'h300181 {
    field RxEnDlyTg1_u1_p3 @0 {
       bits 11;
       access rw;
       reset 11'h100;
    }
  }
  register RxEnDlyTg2_u1_p3 @'h300182 {
    field RxEnDlyTg2_u1_p3 @0 {
       bits 11;
       access rw;
       reset 11'h100;
    }
  }
  register RxEnDlyTg3_u1_p3 @'h300183 {
    field RxEnDlyTg3_u1_p3 @0 {
       bits 11;
       access rw;
       reset 11'h100;
    }
  }
  register RxClkDlyTg0_u1_p3 @'h30018c {
    field RxClkDlyTg0_u1_p3 @0 {
       bits 6;
       access rw;
       reset 6'h10;
    }
  }
  register RxClkDlyTg1_u1_p3 @'h30018d {
    field RxClkDlyTg1_u1_p3 @0 {
       bits 6;
       access rw;
       reset 6'h10;
    }
  }
  register RxClkDlyTg2_u1_p3 @'h30018e {
    field RxClkDlyTg2_u1_p3 @0 {
       bits 6;
       access rw;
       reset 6'h10;
    }
  }
  register RxClkDlyTg3_u1_p3 @'h30018f {
    field RxClkDlyTg3_u1_p3 @0 {
       bits 6;
       access rw;
       reset 6'h10;
    }
  }
  register RxClkcDlyTg0_u1_p3 @'h300190 {
    field RxClkcDlyTg0_u1_p3 @0 {
       bits 6;
       access rw;
       reset 6'h10;
    }
  }
  register RxClkcDlyTg1_u1_p3 @'h300191 {
    field RxClkcDlyTg1_u1_p3 @0 {
       bits 6;
       access rw;
       reset 6'h10;
    }
  }
  register RxClkcDlyTg2_u1_p3 @'h300192 {
    field RxClkcDlyTg2_u1_p3 @0 {
       bits 6;
       access rw;
       reset 6'h10;
    }
  }
  register RxClkcDlyTg3_u1_p3 @'h300193 {
    field RxClkcDlyTg3_u1_p3 @0 {
       bits 6;
       access rw;
       reset 6'h10;
    }
  }
  register TxDqDlyTg0_r1_p3 @'h3001c0 {
    field TxDqDlyTg0_r1_p3 @0 {
       bits 9;
       access rw;
       reset 9'h10;
    }
  }
  register TxDqDlyTg1_r1_p3 @'h3001c1 {
    field TxDqDlyTg1_r1_p3 @0 {
       bits 9;
       access rw;
       reset 9'h10;
    }
  }
  register TxDqDlyTg2_r1_p3 @'h3001c2 {
    field TxDqDlyTg2_r1_p3 @0 {
       bits 9;
       access rw;
       reset 9'h10;
    }
  }
  register TxDqDlyTg3_r1_p3 @'h3001c3 {
    field TxDqDlyTg3_r1_p3 @0 {
       bits 9;
       access rw;
       reset 9'h10;
    }
  }
  register TxDqsDlyTg0_u1_p3 @'h3001d0 {
    field TxDqsDlyTg0_u1_p3 @0 {
       bits 10;
       access rw;
       reset 10'h100;
    }
  }
  register TxDqsDlyTg1_u1_p3 @'h3001d1 {
    field TxDqsDlyTg1_u1_p3 @0 {
       bits 10;
       access rw;
       reset 10'h100;
    }
  }
  register TxDqsDlyTg2_u1_p3 @'h3001d2 {
    field TxDqsDlyTg2_u1_p3 @0 {
       bits 10;
       access rw;
       reset 10'h100;
    }
  }
  register TxDqsDlyTg3_u1_p3 @'h3001d3 {
    field TxDqsDlyTg3_u1_p3 @0 {
       bits 10;
       access rw;
       reset 10'h100;
    }
  }
  register TxDqDlyTg0_r2_p3 @'h3002c0 {
    field TxDqDlyTg0_r2_p3 @0 {
       bits 9;
       access rw;
       reset 9'h10;
    }
  }
  register TxDqDlyTg1_r2_p3 @'h3002c1 {
    field TxDqDlyTg1_r2_p3 @0 {
       bits 9;
       access rw;
       reset 9'h10;
    }
  }
  register TxDqDlyTg2_r2_p3 @'h3002c2 {
    field TxDqDlyTg2_r2_p3 @0 {
       bits 9;
       access rw;
       reset 9'h10;
    }
  }
  register TxDqDlyTg3_r2_p3 @'h3002c3 {
    field TxDqDlyTg3_r2_p3 @0 {
       bits 9;
       access rw;
       reset 9'h10;
    }
  }
  register TxDqDlyTg0_r3_p3 @'h3003c0 {
    field TxDqDlyTg0_r3_p3 @0 {
       bits 9;
       access rw;
       reset 9'h10;
    }
  }
  register TxDqDlyTg1_r3_p3 @'h3003c1 {
    field TxDqDlyTg1_r3_p3 @0 {
       bits 9;
       access rw;
       reset 9'h10;
    }
  }
  register TxDqDlyTg2_r3_p3 @'h3003c2 {
    field TxDqDlyTg2_r3_p3 @0 {
       bits 9;
       access rw;
       reset 9'h10;
    }
  }
  register TxDqDlyTg3_r3_p3 @'h3003c3 {
    field TxDqDlyTg3_r3_p3 @0 {
       bits 9;
       access rw;
       reset 9'h10;
    }
  }
  register TxDqDlyTg0_r4_p3 @'h3004c0 {
    field TxDqDlyTg0_r4_p3 @0 {
       bits 9;
       access rw;
       reset 9'h10;
    }
  }
  register TxDqDlyTg1_r4_p3 @'h3004c1 {
    field TxDqDlyTg1_r4_p3 @0 {
       bits 9;
       access rw;
       reset 9'h10;
    }
  }
  register TxDqDlyTg2_r4_p3 @'h3004c2 {
    field TxDqDlyTg2_r4_p3 @0 {
       bits 9;
       access rw;
       reset 9'h10;
    }
  }
  register TxDqDlyTg3_r4_p3 @'h3004c3 {
    field TxDqDlyTg3_r4_p3 @0 {
       bits 9;
       access rw;
       reset 9'h10;
    }
  }
  register TxDqDlyTg0_r5_p3 @'h3005c0 {
    field TxDqDlyTg0_r5_p3 @0 {
       bits 9;
       access rw;
       reset 9'h10;
    }
  }
  register TxDqDlyTg1_r5_p3 @'h3005c1 {
    field TxDqDlyTg1_r5_p3 @0 {
       bits 9;
       access rw;
       reset 9'h10;
    }
  }
  register TxDqDlyTg2_r5_p3 @'h3005c2 {
    field TxDqDlyTg2_r5_p3 @0 {
       bits 9;
       access rw;
       reset 9'h10;
    }
  }
  register TxDqDlyTg3_r5_p3 @'h3005c3 {
    field TxDqDlyTg3_r5_p3 @0 {
       bits 9;
       access rw;
       reset 9'h10;
    }
  }
  register TxDqDlyTg0_r6_p3 @'h3006c0 {
    field TxDqDlyTg0_r6_p3 @0 {
       bits 9;
       access rw;
       reset 9'h10;
    }
  }
  register TxDqDlyTg1_r6_p3 @'h3006c1 {
    field TxDqDlyTg1_r6_p3 @0 {
       bits 9;
       access rw;
       reset 9'h10;
    }
  }
  register TxDqDlyTg2_r6_p3 @'h3006c2 {
    field TxDqDlyTg2_r6_p3 @0 {
       bits 9;
       access rw;
       reset 9'h10;
    }
  }
  register TxDqDlyTg3_r6_p3 @'h3006c3 {
    field TxDqDlyTg3_r6_p3 @0 {
       bits 9;
       access rw;
       reset 9'h10;
    }
  }
  register TxDqDlyTg0_r7_p3 @'h3007c0 {
    field TxDqDlyTg0_r7_p3 @0 {
       bits 9;
       access rw;
       reset 9'h10;
    }
  }
  register TxDqDlyTg1_r7_p3 @'h3007c1 {
    field TxDqDlyTg1_r7_p3 @0 {
       bits 9;
       access rw;
       reset 9'h10;
    }
  }
  register TxDqDlyTg2_r7_p3 @'h3007c2 {
    field TxDqDlyTg2_r7_p3 @0 {
       bits 9;
       access rw;
       reset 9'h10;
    }
  }
  register TxDqDlyTg3_r7_p3 @'h3007c3 {
    field TxDqDlyTg3_r7_p3 @0 {
       bits 9;
       access rw;
       reset 9'h10;
    }
  }
  register TxDqDlyTg0_r8_p3 @'h3008c0 {
    field TxDqDlyTg0_r8_p3 @0 {
       bits 9;
       access rw;
       reset 9'h10;
    }
  }
  register TxDqDlyTg1_r8_p3 @'h3008c1 {
    field TxDqDlyTg1_r8_p3 @0 {
       bits 9;
       access rw;
       reset 9'h10;
    }
  }
  register TxDqDlyTg2_r8_p3 @'h3008c2 {
    field TxDqDlyTg2_r8_p3 @0 {
       bits 9;
       access rw;
       reset 9'h10;
    }
  }
  register TxDqDlyTg3_r8_p3 @'h3008c3 {
    field TxDqDlyTg3_r8_p3 @0 {
       bits 9;
       access rw;
       reset 9'h10;
    }
  }
}
block dwc_ddrphy_top_DWC_DDRPHYA_DBYTE8 {
  endian little;
  bytes 2;
  register DbyteMiscMode @'h0 {
    field Reserved @0 {
       bits 2;
    }
    field DByteDisable @2 {
       bits 1;
       access rw;
       reset 1'h0;
    }
  }
  register TsmByte0 @'h1 {
    field RFU_TsmByte0 @0 {
       bits 16;
       access rw;
       reset 16'h0;
    }
  }
  register TrainingParam @'h2 {
    field RFU_TrainingParam @0 {
       bits 16;
       access rw;
       reset 16'h0;
    }
  }
  register UseDqsEnReplica_p0 @'h3 {
    field UseDqsEnReplica_p0 @0 {
       bits 1;
       access rw;
       reset 1'h0;
    }
  }
  register RxTrainPatternEnable @'h10 {
    field RxTrainPatternEnable @0 {
       bits 1;
       access rw;
       reset 1'h0;
    }
  }
  register TsmByte1 @'h11 {
    field RFU_TsmByte1 @0 {
       bits 16;
       access rw;
       reset 16'h0;
    }
  }
  register TsmByte2 @'h12 {
    field RFU_TsmByte2 @0 {
       bits 16;
       access rw;
       reset 16'h0;
    }
  }
  register TsmByte3 @'h13 {
    field RFU_TsmByte3 @0 {
       bits 9;
       access rw;
       reset 9'h0;
    }
  }
  register TsmByte4 @'h14 {
    field RFU_TsmByte4 @0 {
       bits 4;
       access rw;
       reset 4'h0;
    }
  }
  register TestModeConfig @'h17 {
    field RFU_TestModeConfig @0 {
       bits 10;
       access rw;
       reset 10'h0;
    }
  }
  register TsmByte5 @'h18 {
    field RFU_TsmByte5 @0 {
       bits 16;
       access rw;
       reset 16'h0;
    }
  }
  register MtestMuxSel @'h1a {
    field MtestMuxSel @0 {
       bits 6;
       access rw;
       reset 6'h0;
    }
  }
  register DtsmTrainModeCtrl @'h1f {
    field RFU_DtsmTrainModeCtrl @0 {
       bits 4;
       access rw;
       reset 4'h0;
    }
  }
  register DFIMRL_p0 @'h20 {
    field DFIMRL_p0 @0 {
       bits 5;
       access rw;
       reset 5'h6;
    }
  }
  register AsyncDbyteMode @'h24 {
    field AsyncDbyteMode @0 {
       bits 9;
       access rw;
       reset 9'h0;
    }
  }
  register AsyncDbyteTxEn @'h26 {
    field AsyncDbyteTxEn @0 {
       bits 12;
       access rw;
       reset 12'h0;
    }
  }
  register AsyncDbyteTxData @'h28 {
    field AsyncDbyteTxData @0 {
       bits 12;
       access rw;
       reset 12'h0;
    }
  }
  register AsyncDbyteRxData @'h2a {
    field AsyncDbyteRxData @0 {
       bits 12;
       access ro;
       reset 12'h0;
    }
  }
  register VrefDAC1_r0 @'h30 {
    field VrefDAC1_r0 @0 {
       bits 7;
       access rw;
       reset 7'h0;
    }
  }
  register TrainingCntr_r0 @'h32 {
    field RFU_TrainingCntr_r0 @0 {
       bits 16;
       access rw;
       reset 16'h0;
    }
  }
  register VrefDAC0_r0 @'h40 {
    field VrefDAC0_r0 @0 {
       bits 7;
       access rw;
       reset 7'h0;
    }
  }
  register TxImpedanceCtrl0_b0_p0 @'h41 {
    field DrvStrenDqP @0 {
       bits 6;
       access rw;
       reset 6'h3f;
    }
    field DrvStrenDqN @6 {
       bits 6;
       access rw;
       reset 6'h3f;
    }
  }
  register DqDqsRcvCntrl_b0_p0 @'h43 {
    field SelAnalogVref @0 {
       bits 1;
       access rw;
       reset 1'h0;
    }
    field ExtVrefRange @1 {
       bits 1;
       access rw;
       reset 1'h0;
    }
    field DfeCtrl @2 {
       bits 2;
       access rw;
       reset 2'h0;
    }
    field MajorModeDbyte @4 {
       bits 3;
       access rw;
       reset 3'h3;
    }
    field GainCurrAdj @7 {
       bits 5;
       access rw;
       reset 5'hb;
    }
    field Reserved @12 {
       bits 4;
    }
  }
  register TxEqualizationMode_p0 @'h48 {
    field TxEqMode @0 {
       bits 2;
       access rw;
       reset 2'h0;
    }
  }
  register TxImpedanceCtrl1_b0_p0 @'h49 {
    field DrvStrenFSDqP @0 {
       bits 6;
       access rw;
       reset 6'h3f;
    }
    field DrvStrenFSDqN @6 {
       bits 6;
       access rw;
       reset 6'h3f;
    }
  }
  register DqDqsRcvCntrl1 @'h4a {
    field PowerDownRcvr @0 {
       bits 9;
       access rw;
       reset 9'h0;
    }
    field PowerDownRcvrDqs @9 {
       bits 1;
       access rw;
       reset 1'h0;
    }
    field RxPadStandbyEn @10 {
       bits 1;
       access rw;
       reset 1'h1;
    }
    field EnLPReqPDR @11 {
       bits 1;
       access rw;
       reset 1'h0;
    }
  }
  register TxImpedanceCtrl2_b0_p0 @'h4b {
    field DrvStrenEQHiDqP @0 {
       bits 6;
       access rw;
       reset 6'h0;
    }
    field DrvStrenEQLoDqN @6 {
       bits 6;
       access rw;
       reset 6'h0;
    }
  }
  register DqDqsRcvCntrl2_p0 @'h4c {
    field EnRxAgressivePDR @0 {
       bits 1;
       access rw;
       reset 1'h0;
    }
  }
  register TxOdtDrvStren_b0_p0 @'h4d {
    field ODTStrenP @0 {
       bits 6;
       access rw;
       reset 6'h0;
    }
    field ODTStrenN @6 {
       bits 6;
       access rw;
       reset 6'h0;
    }
  }
  register RxFifoCheckStatus @'h56 {
    field RxFifoLocErr @0 {
       bits 1;
       access ro;
       reset 1'h0;
    }
    field RxFifoLocUErr @1 {
       bits 1;
       access ro;
       reset 1'h0;
    }
  }
  register RxFifoCheckErrValues @'h57 {
    field RxFifoRdLocErrValue @0 {
       bits 4;
       access ro;
       reset 4'h0;
    }
    field RxFifoWrLocErrValue @4 {
       bits 4;
       access ro;
       reset 4'h0;
    }
    field RxFifoRdLocUErrValue @8 {
       bits 4;
       access ro;
       reset 4'h0;
    }
    field RxFifoWrLocUErrValue @12 {
       bits 4;
       access ro;
       reset 4'h0;
    }
  }
  register RxFifoInfo @'h58 {
    field RxFifoRdLoc @0 {
       bits 4;
       access ro;
       reset 4'h0;
    }
    field RxFifoWrLoc @4 {
       bits 4;
       access ro;
       reset 4'h0;
    }
    field RxFifoRdLocU @8 {
       bits 4;
       access ro;
       reset 4'h0;
    }
    field RxFifoWrLocU @12 {
       bits 4;
       access ro;
       reset 4'h0;
    }
  }
  register RxFifoVisibility @'h59 {
    field RxFifoRdPtr @0 {
       bits 3;
       access rw;
       reset 3'h0;
    }
    field RxFifoRdPtrOvr @3 {
       bits 1;
       access rw;
       reset 1'h0;
    }
    field RxFifoRdEn @4 {
       bits 1;
       access rw;
       reset 1'h0;
    }
  }
  register RxFifoContentsDQ3210 @'h5a {
    field RxFifoContentsDQ3210 @0 {
       bits 16;
       access ro;
       reset 16'h0;
    }
  }
  register RxFifoContentsDQ7654 @'h5b {
    field RxFifoContentsDQ7654 @0 {
       bits 16;
       access ro;
       reset 16'h0;
    }
  }
  register RxFifoContentsDBI @'h5c {
    field RxFifoContentsDBI @0 {
       bits 4;
       access ro;
       reset 4'h0;
    }
  }
  register TxSlewRate_b0_p0 @'h5f {
    field TxPreP @0 {
       bits 4;
       access rw;
       reset 4'hf;
    }
    field TxPreN @4 {
       bits 4;
       access rw;
       reset 4'hf;
    }
    field TxPreDrvMode @8 {
       bits 3;
       access rw;
       reset 3'h7;
    }
  }
  register TrainingIncDecDtsmEn_r0 @'h62 {
    field TrainingIncDecDtsmEn_r0 @0 {
       bits 9;
       access rw;
       reset 9'h0;
    }
  }
  register RxPBDlyTg0_r0 @'h68 {
    field RxPBDlyTg0_r0 @0 {
       bits 7;
       access rw;
       reset 7'h0;
    }
  }
  register RxPBDlyTg1_r0 @'h69 {
    field RxPBDlyTg1_r0 @0 {
       bits 7;
       access rw;
       reset 7'h0;
    }
  }
  register RxPBDlyTg2_r0 @'h6a {
    field RxPBDlyTg2_r0 @0 {
       bits 7;
       access rw;
       reset 7'h0;
    }
  }
  register RxPBDlyTg3_r0 @'h6b {
    field RxPBDlyTg3_r0 @0 {
       bits 7;
       access rw;
       reset 7'h0;
    }
  }
  register RxEnDlyTg0_u0_p0 @'h80 {
    field RxEnDlyTg0_u0_p0 @0 {
       bits 11;
       access rw;
       reset 11'h100;
    }
  }
  register RxEnDlyTg1_u0_p0 @'h81 {
    field RxEnDlyTg1_u0_p0 @0 {
       bits 11;
       access rw;
       reset 11'h100;
    }
  }
  register RxEnDlyTg2_u0_p0 @'h82 {
    field RxEnDlyTg2_u0_p0 @0 {
       bits 11;
       access rw;
       reset 11'h100;
    }
  }
  register RxEnDlyTg3_u0_p0 @'h83 {
    field RxEnDlyTg3_u0_p0 @0 {
       bits 11;
       access rw;
       reset 11'h100;
    }
  }
  register RxClkDlyTg0_u0_p0 @'h8c {
    field RxClkDlyTg0_u0_p0 @0 {
       bits 6;
       access rw;
       reset 6'h10;
    }
  }
  register RxClkDlyTg1_u0_p0 @'h8d {
    field RxClkDlyTg1_u0_p0 @0 {
       bits 6;
       access rw;
       reset 6'h10;
    }
  }
  register RxClkDlyTg2_u0_p0 @'h8e {
    field RxClkDlyTg2_u0_p0 @0 {
       bits 6;
       access rw;
       reset 6'h10;
    }
  }
  register RxClkDlyTg3_u0_p0 @'h8f {
    field RxClkDlyTg3_u0_p0 @0 {
       bits 6;
       access rw;
       reset 6'h10;
    }
  }
  register RxClkcDlyTg0_u0_p0 @'h90 {
    field RxClkcDlyTg0_u0_p0 @0 {
       bits 6;
       access rw;
       reset 6'h10;
    }
  }
  register RxClkcDlyTg1_u0_p0 @'h91 {
    field RxClkcDlyTg1_u0_p0 @0 {
       bits 6;
       access rw;
       reset 6'h10;
    }
  }
  register RxClkcDlyTg2_u0_p0 @'h92 {
    field RxClkcDlyTg2_u0_p0 @0 {
       bits 6;
       access rw;
       reset 6'h10;
    }
  }
  register RxClkcDlyTg3_u0_p0 @'h93 {
    field RxClkcDlyTg3_u0_p0 @0 {
       bits 6;
       access rw;
       reset 6'h10;
    }
  }
  register Dq0LnSel @'ha0 {
    field Dq0LnSel @0 {
       bits 3;
       access rw;
       reset 3'h0;
    }
  }
  register Dq1LnSel @'ha1 {
    field Dq1LnSel @0 {
       bits 3;
       access rw;
       reset 3'h1;
    }
  }
  register Dq2LnSel @'ha2 {
    field Dq2LnSel @0 {
       bits 3;
       access rw;
       reset 3'h2;
    }
  }
  register Dq3LnSel @'ha3 {
    field Dq3LnSel @0 {
       bits 3;
       access rw;
       reset 3'h3;
    }
  }
  register Dq4LnSel @'ha4 {
    field Dq4LnSel @0 {
       bits 3;
       access rw;
       reset 3'h4;
    }
  }
  register Dq5LnSel @'ha5 {
    field Dq5LnSel @0 {
       bits 3;
       access rw;
       reset 3'h5;
    }
  }
  register Dq6LnSel @'ha6 {
    field Dq6LnSel @0 {
       bits 3;
       access rw;
       reset 3'h6;
    }
  }
  register Dq7LnSel @'ha7 {
    field Dq7LnSel @0 {
       bits 3;
       access rw;
       reset 3'h7;
    }
  }
  register PptCtlStatic @'haa {
    field RFU_PptCtlStatic @0 {
       bits 12;
       access rw;
       reset 12'h0;
    }
  }
  register PptCtlDyn @'hab {
    field RFU_PptCtlDyn @0 {
       bits 2;
       access rw;
       reset 2'h0;
    }
  }
  register PptInfo @'hac {
    field PptInfo @0 {
       bits 16;
       access ro;
       reset 16'h0;
    }
  }
  register PptRxEnEvnt @'had {
    field RFU_PptRxEnEvnt @0 {
       bits 2;
       access rw;
       reset 2'h0;
    }
  }
  register PptDqsCntInvTrnTg0_p0 @'hae {
    field PptDqsCntInvTrnTg0_p0 @0 {
       bits 16;
       access rw;
       reset 16'h0;
    }
  }
  register PptDqsCntInvTrnTg1_p0 @'haf {
    field PptDqsCntInvTrnTg1_p0 @0 {
       bits 16;
       access rw;
       reset 16'h0;
    }
  }
  register DtsmBlankingCtrl @'hb1 {
    field RFU_DtsmBlankingCtrl @0 {
       bits 10;
       access rw;
       reset 10'h0;
    }
  }
  register Tsm0_i0 @'hb2 {
    field RFU_Tsm0_i0 @0 {
       bits 14;
       access rw;
       reset 14'h0;
    }
  }
  register Tsm1_i0 @'hb3 {
    field RFU_Tsm1_i0 @0 {
       bits 16;
       access ro;
       reset 16'h0;
    }
  }
  register Tsm2_i0 @'hb4 {
    field RFU_Tsm2_i0 @0 {
       bits 1;
       access rw;
       reset 1'h0;
    }
  }
  register Tsm3 @'hb5 {
    field RFU_Tsm3 @0 {
       bits 10;
       access rw;
       reset 10'h0;
    }
  }
  register TxChkDataSelects @'hb6 {
    field RFU_TxChkDataSelects @0 {
       bits 2;
       access rw;
       reset 2'h0;
    }
  }
  register DtsmUpThldXingInd @'hb7 {
    field DtsmUpThldXingInd @0 {
       bits 9;
       access ro;
       reset 9'h0;
    }
  }
  register DtsmLoThldXingInd @'hb8 {
    field DtsmLoThldXingInd @0 {
       bits 9;
       access ro;
       reset 9'h0;
    }
  }
  register DbyteAllDtsmCtrl0 @'hb9 {
    field RFU_DbyteAllDtsmCtrl0 @0 {
       bits 9;
       access rw;
       reset 9'h0;
    }
  }
  register DbyteAllDtsmCtrl1 @'hba {
    field RFU_DbyteAllDtsmCtrl1 @0 {
       bits 9;
       access rw;
       reset 9'h0;
    }
  }
  register DbyteAllDtsmCtrl2 @'hbb {
    field RFU_DbyteAllDtsmCtrl2 @0 {
       bits 9;
       access rw;
       reset 9'h0;
    }
  }
  register TxDqDlyTg0_r0_p0 @'hc0 {
    field TxDqDlyTg0_r0_p0 @0 {
       bits 9;
       access rw;
       reset 9'h10;
    }
  }
  register TxDqDlyTg1_r0_p0 @'hc1 {
    field TxDqDlyTg1_r0_p0 @0 {
       bits 9;
       access rw;
       reset 9'h10;
    }
  }
  register TxDqDlyTg2_r0_p0 @'hc2 {
    field TxDqDlyTg2_r0_p0 @0 {
       bits 9;
       access rw;
       reset 9'h10;
    }
  }
  register TxDqDlyTg3_r0_p0 @'hc3 {
    field TxDqDlyTg3_r0_p0 @0 {
       bits 9;
       access rw;
       reset 9'h10;
    }
  }
  register TxDqsDlyTg0_u0_p0 @'hd0 {
    field TxDqsDlyTg0_u0_p0 @0 {
       bits 10;
       access rw;
       reset 10'h100;
    }
  }
  register TxDqsDlyTg1_u0_p0 @'hd1 {
    field TxDqsDlyTg1_u0_p0 @0 {
       bits 10;
       access rw;
       reset 10'h100;
    }
  }
  register TxDqsDlyTg2_u0_p0 @'hd2 {
    field TxDqsDlyTg2_u0_p0 @0 {
       bits 10;
       access rw;
       reset 10'h100;
    }
  }
  register TxDqsDlyTg3_u0_p0 @'hd3 {
    field TxDqsDlyTg3_u0_p0 @0 {
       bits 10;
       access rw;
       reset 10'h100;
    }
  }
  register DxLcdlStatus @'he4 {
    field DxLcdlFineSnapVal @0 {
       bits 10;
       access ro;
       reset 10'h0;
    }
    field DxLcdlPhdSnapVal @10 {
       bits 1;
       access ro;
       reset 1'h0;
    }
    field DxLcdlStickyLock @11 {
       bits 1;
       access ro;
       reset 1'h0;
    }
    field DxLcdlStickyUnlock @12 {
       bits 1;
       access ro;
       reset 1'h0;
    }
    field DxLcdlLiveLock @13 {
       bits 1;
       access ro;
       reset 1'h0;
    }
  }
  register VrefDAC1_r1 @'h130 {
    field VrefDAC1_r1 @0 {
       bits 7;
       access rw;
       reset 7'h0;
    }
  }
  register TrainingCntr_r1 @'h132 {
    field RFU_TrainingCntr_r1 @0 {
       bits 16;
       access rw;
       reset 16'h0;
    }
  }
  register VrefDAC0_r1 @'h140 {
    field VrefDAC0_r1 @0 {
       bits 7;
       access rw;
       reset 7'h0;
    }
  }
  register TxImpedanceCtrl0_b1_p0 @'h141 {
    field DrvStrenDqP @0 {
       bits 6;
       access rw;
       reset 6'h3f;
    }
    field DrvStrenDqN @6 {
       bits 6;
       access rw;
       reset 6'h3f;
    }
  }
  register DqDqsRcvCntrl_b1_p0 @'h143 {
    field SelAnalogVref @0 {
       bits 1;
       access rw;
       reset 1'h0;
    }
    field ExtVrefRange @1 {
       bits 1;
       access rw;
       reset 1'h0;
    }
    field DfeCtrl @2 {
       bits 2;
       access rw;
       reset 2'h0;
    }
    field MajorModeDbyte @4 {
       bits 3;
       access rw;
       reset 3'h3;
    }
    field GainCurrAdj @7 {
       bits 5;
       access rw;
       reset 5'hb;
    }
    field Reserved @12 {
       bits 4;
    }
  }
  register TxImpedanceCtrl1_b1_p0 @'h149 {
    field DrvStrenFSDqP @0 {
       bits 6;
       access rw;
       reset 6'h3f;
    }
    field DrvStrenFSDqN @6 {
       bits 6;
       access rw;
       reset 6'h3f;
    }
  }
  register TxImpedanceCtrl2_b1_p0 @'h14b {
    field DrvStrenEQHiDqP @0 {
       bits 6;
       access rw;
       reset 6'h0;
    }
    field DrvStrenEQLoDqN @6 {
       bits 6;
       access rw;
       reset 6'h0;
    }
  }
  register TxOdtDrvStren_b1_p0 @'h14d {
    field ODTStrenP @0 {
       bits 6;
       access rw;
       reset 6'h0;
    }
    field ODTStrenN @6 {
       bits 6;
       access rw;
       reset 6'h0;
    }
  }
  register TxSlewRate_b1_p0 @'h15f {
    field TxPreP @0 {
       bits 4;
       access rw;
       reset 4'hf;
    }
    field TxPreN @4 {
       bits 4;
       access rw;
       reset 4'hf;
    }
    field TxPreDrvMode @8 {
       bits 3;
       access rw;
       reset 3'h7;
    }
  }
  register TrainingIncDecDtsmEn_r1 @'h162 {
    field TrainingIncDecDtsmEn_r1 @0 {
       bits 9;
       access rw;
       reset 9'h0;
    }
  }
  register RxPBDlyTg0_r1 @'h168 {
    field RxPBDlyTg0_r1 @0 {
       bits 7;
       access rw;
       reset 7'h0;
    }
  }
  register RxPBDlyTg1_r1 @'h169 {
    field RxPBDlyTg1_r1 @0 {
       bits 7;
       access rw;
       reset 7'h0;
    }
  }
  register RxPBDlyTg2_r1 @'h16a {
    field RxPBDlyTg2_r1 @0 {
       bits 7;
       access rw;
       reset 7'h0;
    }
  }
  register RxPBDlyTg3_r1 @'h16b {
    field RxPBDlyTg3_r1 @0 {
       bits 7;
       access rw;
       reset 7'h0;
    }
  }
  register RxEnDlyTg0_u1_p0 @'h180 {
    field RxEnDlyTg0_u1_p0 @0 {
       bits 11;
       access rw;
       reset 11'h100;
    }
  }
  register RxEnDlyTg1_u1_p0 @'h181 {
    field RxEnDlyTg1_u1_p0 @0 {
       bits 11;
       access rw;
       reset 11'h100;
    }
  }
  register RxEnDlyTg2_u1_p0 @'h182 {
    field RxEnDlyTg2_u1_p0 @0 {
       bits 11;
       access rw;
       reset 11'h100;
    }
  }
  register RxEnDlyTg3_u1_p0 @'h183 {
    field RxEnDlyTg3_u1_p0 @0 {
       bits 11;
       access rw;
       reset 11'h100;
    }
  }
  register RxClkDlyTg0_u1_p0 @'h18c {
    field RxClkDlyTg0_u1_p0 @0 {
       bits 6;
       access rw;
       reset 6'h10;
    }
  }
  register RxClkDlyTg1_u1_p0 @'h18d {
    field RxClkDlyTg1_u1_p0 @0 {
       bits 6;
       access rw;
       reset 6'h10;
    }
  }
  register RxClkDlyTg2_u1_p0 @'h18e {
    field RxClkDlyTg2_u1_p0 @0 {
       bits 6;
       access rw;
       reset 6'h10;
    }
  }
  register RxClkDlyTg3_u1_p0 @'h18f {
    field RxClkDlyTg3_u1_p0 @0 {
       bits 6;
       access rw;
       reset 6'h10;
    }
  }
  register RxClkcDlyTg0_u1_p0 @'h190 {
    field RxClkcDlyTg0_u1_p0 @0 {
       bits 6;
       access rw;
       reset 6'h10;
    }
  }
  register RxClkcDlyTg1_u1_p0 @'h191 {
    field RxClkcDlyTg1_u1_p0 @0 {
       bits 6;
       access rw;
       reset 6'h10;
    }
  }
  register RxClkcDlyTg2_u1_p0 @'h192 {
    field RxClkcDlyTg2_u1_p0 @0 {
       bits 6;
       access rw;
       reset 6'h10;
    }
  }
  register RxClkcDlyTg3_u1_p0 @'h193 {
    field RxClkcDlyTg3_u1_p0 @0 {
       bits 6;
       access rw;
       reset 6'h10;
    }
  }
  register Tsm0_i1 @'h1b2 {
    field RFU_Tsm0_i1 @0 {
       bits 14;
       access rw;
       reset 14'h0;
    }
  }
  register Tsm1_i1 @'h1b3 {
    field RFU_Tsm1_i1 @0 {
       bits 16;
       access ro;
       reset 16'h0;
    }
  }
  register Tsm2_i1 @'h1b4 {
    field RFU_Tsm2_i1 @0 {
       bits 1;
       access rw;
       reset 1'h0;
    }
  }
  register TxDqDlyTg0_r1_p0 @'h1c0 {
    field TxDqDlyTg0_r1_p0 @0 {
       bits 9;
       access rw;
       reset 9'h10;
    }
  }
  register TxDqDlyTg1_r1_p0 @'h1c1 {
    field TxDqDlyTg1_r1_p0 @0 {
       bits 9;
       access rw;
       reset 9'h10;
    }
  }
  register TxDqDlyTg2_r1_p0 @'h1c2 {
    field TxDqDlyTg2_r1_p0 @0 {
       bits 9;
       access rw;
       reset 9'h10;
    }
  }
  register TxDqDlyTg3_r1_p0 @'h1c3 {
    field TxDqDlyTg3_r1_p0 @0 {
       bits 9;
       access rw;
       reset 9'h10;
    }
  }
  register TxDqsDlyTg0_u1_p0 @'h1d0 {
    field TxDqsDlyTg0_u1_p0 @0 {
       bits 10;
       access rw;
       reset 10'h100;
    }
  }
  register TxDqsDlyTg1_u1_p0 @'h1d1 {
    field TxDqsDlyTg1_u1_p0 @0 {
       bits 10;
       access rw;
       reset 10'h100;
    }
  }
  register TxDqsDlyTg2_u1_p0 @'h1d2 {
    field TxDqsDlyTg2_u1_p0 @0 {
       bits 10;
       access rw;
       reset 10'h100;
    }
  }
  register TxDqsDlyTg3_u1_p0 @'h1d3 {
    field TxDqsDlyTg3_u1_p0 @0 {
       bits 10;
       access rw;
       reset 10'h100;
    }
  }
  register VrefDAC1_r2 @'h230 {
    field VrefDAC1_r2 @0 {
       bits 7;
       access rw;
       reset 7'h0;
    }
  }
  register TrainingCntr_r2 @'h232 {
    field RFU_TrainingCntr_r2 @0 {
       bits 16;
       access rw;
       reset 16'h0;
    }
  }
  register VrefDAC0_r2 @'h240 {
    field VrefDAC0_r2 @0 {
       bits 7;
       access rw;
       reset 7'h0;
    }
  }
  register TrainingIncDecDtsmEn_r2 @'h262 {
    field TrainingIncDecDtsmEn_r2 @0 {
       bits 9;
       access rw;
       reset 9'h0;
    }
  }
  register RxPBDlyTg0_r2 @'h268 {
    field RxPBDlyTg0_r2 @0 {
       bits 7;
       access rw;
       reset 7'h0;
    }
  }
  register RxPBDlyTg1_r2 @'h269 {
    field RxPBDlyTg1_r2 @0 {
       bits 7;
       access rw;
       reset 7'h0;
    }
  }
  register RxPBDlyTg2_r2 @'h26a {
    field RxPBDlyTg2_r2 @0 {
       bits 7;
       access rw;
       reset 7'h0;
    }
  }
  register RxPBDlyTg3_r2 @'h26b {
    field RxPBDlyTg3_r2 @0 {
       bits 7;
       access rw;
       reset 7'h0;
    }
  }
  register Tsm0_i2 @'h2b2 {
    field RFU_Tsm0_i2 @0 {
       bits 14;
       access rw;
       reset 14'h0;
    }
  }
  register Tsm1_i2 @'h2b3 {
    field RFU_Tsm1_i2 @0 {
       bits 16;
       access ro;
       reset 16'h0;
    }
  }
  register Tsm2_i2 @'h2b4 {
    field RFU_Tsm2_i2 @0 {
       bits 1;
       access rw;
       reset 1'h0;
    }
  }
  register TxDqDlyTg0_r2_p0 @'h2c0 {
    field TxDqDlyTg0_r2_p0 @0 {
       bits 9;
       access rw;
       reset 9'h10;
    }
  }
  register TxDqDlyTg1_r2_p0 @'h2c1 {
    field TxDqDlyTg1_r2_p0 @0 {
       bits 9;
       access rw;
       reset 9'h10;
    }
  }
  register TxDqDlyTg2_r2_p0 @'h2c2 {
    field TxDqDlyTg2_r2_p0 @0 {
       bits 9;
       access rw;
       reset 9'h10;
    }
  }
  register TxDqDlyTg3_r2_p0 @'h2c3 {
    field TxDqDlyTg3_r2_p0 @0 {
       bits 9;
       access rw;
       reset 9'h10;
    }
  }
  register VrefDAC1_r3 @'h330 {
    field VrefDAC1_r3 @0 {
       bits 7;
       access rw;
       reset 7'h0;
    }
  }
  register TrainingCntr_r3 @'h332 {
    field RFU_TrainingCntr_r3 @0 {
       bits 16;
       access rw;
       reset 16'h0;
    }
  }
  register VrefDAC0_r3 @'h340 {
    field VrefDAC0_r3 @0 {
       bits 7;
       access rw;
       reset 7'h0;
    }
  }
  register TrainingIncDecDtsmEn_r3 @'h362 {
    field TrainingIncDecDtsmEn_r3 @0 {
       bits 9;
       access rw;
       reset 9'h0;
    }
  }
  register RxPBDlyTg0_r3 @'h368 {
    field RxPBDlyTg0_r3 @0 {
       bits 7;
       access rw;
       reset 7'h0;
    }
  }
  register RxPBDlyTg1_r3 @'h369 {
    field RxPBDlyTg1_r3 @0 {
       bits 7;
       access rw;
       reset 7'h0;
    }
  }
  register RxPBDlyTg2_r3 @'h36a {
    field RxPBDlyTg2_r3 @0 {
       bits 7;
       access rw;
       reset 7'h0;
    }
  }
  register RxPBDlyTg3_r3 @'h36b {
    field RxPBDlyTg3_r3 @0 {
       bits 7;
       access rw;
       reset 7'h0;
    }
  }
  register Tsm0_i3 @'h3b2 {
    field RFU_Tsm0_i3 @0 {
       bits 14;
       access rw;
       reset 14'h0;
    }
  }
  register Tsm1_i3 @'h3b3 {
    field RFU_Tsm1_i3 @0 {
       bits 16;
       access ro;
       reset 16'h0;
    }
  }
  register Tsm2_i3 @'h3b4 {
    field RFU_Tsm2_i3 @0 {
       bits 1;
       access rw;
       reset 1'h0;
    }
  }
  register TxDqDlyTg0_r3_p0 @'h3c0 {
    field TxDqDlyTg0_r3_p0 @0 {
       bits 9;
       access rw;
       reset 9'h10;
    }
  }
  register TxDqDlyTg1_r3_p0 @'h3c1 {
    field TxDqDlyTg1_r3_p0 @0 {
       bits 9;
       access rw;
       reset 9'h10;
    }
  }
  register TxDqDlyTg2_r3_p0 @'h3c2 {
    field TxDqDlyTg2_r3_p0 @0 {
       bits 9;
       access rw;
       reset 9'h10;
    }
  }
  register TxDqDlyTg3_r3_p0 @'h3c3 {
    field TxDqDlyTg3_r3_p0 @0 {
       bits 9;
       access rw;
       reset 9'h10;
    }
  }
  register VrefDAC1_r4 @'h430 {
    field VrefDAC1_r4 @0 {
       bits 7;
       access rw;
       reset 7'h0;
    }
  }
  register TrainingCntr_r4 @'h432 {
    field RFU_TrainingCntr_r4 @0 {
       bits 16;
       access rw;
       reset 16'h0;
    }
  }
  register VrefDAC0_r4 @'h440 {
    field VrefDAC0_r4 @0 {
       bits 7;
       access rw;
       reset 7'h0;
    }
  }
  register TrainingIncDecDtsmEn_r4 @'h462 {
    field TrainingIncDecDtsmEn_r4 @0 {
       bits 9;
       access rw;
       reset 9'h0;
    }
  }
  register RxPBDlyTg0_r4 @'h468 {
    field RxPBDlyTg0_r4 @0 {
       bits 7;
       access rw;
       reset 7'h0;
    }
  }
  register RxPBDlyTg1_r4 @'h469 {
    field RxPBDlyTg1_r4 @0 {
       bits 7;
       access rw;
       reset 7'h0;
    }
  }
  register RxPBDlyTg2_r4 @'h46a {
    field RxPBDlyTg2_r4 @0 {
       bits 7;
       access rw;
       reset 7'h0;
    }
  }
  register RxPBDlyTg3_r4 @'h46b {
    field RxPBDlyTg3_r4 @0 {
       bits 7;
       access rw;
       reset 7'h0;
    }
  }
  register Tsm0_i4 @'h4b2 {
    field RFU_Tsm0_i4 @0 {
       bits 14;
       access rw;
       reset 14'h0;
    }
  }
  register Tsm1_i4 @'h4b3 {
    field RFU_Tsm1_i4 @0 {
       bits 16;
       access ro;
       reset 16'h0;
    }
  }
  register Tsm2_i4 @'h4b4 {
    field RFU_Tsm2_i4 @0 {
       bits 1;
       access rw;
       reset 1'h0;
    }
  }
  register TxDqDlyTg0_r4_p0 @'h4c0 {
    field TxDqDlyTg0_r4_p0 @0 {
       bits 9;
       access rw;
       reset 9'h10;
    }
  }
  register TxDqDlyTg1_r4_p0 @'h4c1 {
    field TxDqDlyTg1_r4_p0 @0 {
       bits 9;
       access rw;
       reset 9'h10;
    }
  }
  register TxDqDlyTg2_r4_p0 @'h4c2 {
    field TxDqDlyTg2_r4_p0 @0 {
       bits 9;
       access rw;
       reset 9'h10;
    }
  }
  register TxDqDlyTg3_r4_p0 @'h4c3 {
    field TxDqDlyTg3_r4_p0 @0 {
       bits 9;
       access rw;
       reset 9'h10;
    }
  }
  register VrefDAC1_r5 @'h530 {
    field VrefDAC1_r5 @0 {
       bits 7;
       access rw;
       reset 7'h0;
    }
  }
  register TrainingCntr_r5 @'h532 {
    field RFU_TrainingCntr_r5 @0 {
       bits 16;
       access rw;
       reset 16'h0;
    }
  }
  register VrefDAC0_r5 @'h540 {
    field VrefDAC0_r5 @0 {
       bits 7;
       access rw;
       reset 7'h0;
    }
  }
  register TrainingIncDecDtsmEn_r5 @'h562 {
    field TrainingIncDecDtsmEn_r5 @0 {
       bits 9;
       access rw;
       reset 9'h0;
    }
  }
  register RxPBDlyTg0_r5 @'h568 {
    field RxPBDlyTg0_r5 @0 {
       bits 7;
       access rw;
       reset 7'h0;
    }
  }
  register RxPBDlyTg1_r5 @'h569 {
    field RxPBDlyTg1_r5 @0 {
       bits 7;
       access rw;
       reset 7'h0;
    }
  }
  register RxPBDlyTg2_r5 @'h56a {
    field RxPBDlyTg2_r5 @0 {
       bits 7;
       access rw;
       reset 7'h0;
    }
  }
  register RxPBDlyTg3_r5 @'h56b {
    field RxPBDlyTg3_r5 @0 {
       bits 7;
       access rw;
       reset 7'h0;
    }
  }
  register Tsm0_i5 @'h5b2 {
    field RFU_Tsm0_i5 @0 {
       bits 14;
       access rw;
       reset 14'h0;
    }
  }
  register Tsm1_i5 @'h5b3 {
    field RFU_Tsm1_i5 @0 {
       bits 16;
       access ro;
       reset 16'h0;
    }
  }
  register Tsm2_i5 @'h5b4 {
    field RFU_Tsm2_i5 @0 {
       bits 1;
       access rw;
       reset 1'h0;
    }
  }
  register TxDqDlyTg0_r5_p0 @'h5c0 {
    field TxDqDlyTg0_r5_p0 @0 {
       bits 9;
       access rw;
       reset 9'h10;
    }
  }
  register TxDqDlyTg1_r5_p0 @'h5c1 {
    field TxDqDlyTg1_r5_p0 @0 {
       bits 9;
       access rw;
       reset 9'h10;
    }
  }
  register TxDqDlyTg2_r5_p0 @'h5c2 {
    field TxDqDlyTg2_r5_p0 @0 {
       bits 9;
       access rw;
       reset 9'h10;
    }
  }
  register TxDqDlyTg3_r5_p0 @'h5c3 {
    field TxDqDlyTg3_r5_p0 @0 {
       bits 9;
       access rw;
       reset 9'h10;
    }
  }
  register VrefDAC1_r6 @'h630 {
    field VrefDAC1_r6 @0 {
       bits 7;
       access rw;
       reset 7'h0;
    }
  }
  register TrainingCntr_r6 @'h632 {
    field RFU_TrainingCntr_r6 @0 {
       bits 16;
       access rw;
       reset 16'h0;
    }
  }
  register VrefDAC0_r6 @'h640 {
    field VrefDAC0_r6 @0 {
       bits 7;
       access rw;
       reset 7'h0;
    }
  }
  register TrainingIncDecDtsmEn_r6 @'h662 {
    field TrainingIncDecDtsmEn_r6 @0 {
       bits 9;
       access rw;
       reset 9'h0;
    }
  }
  register RxPBDlyTg0_r6 @'h668 {
    field RxPBDlyTg0_r6 @0 {
       bits 7;
       access rw;
       reset 7'h0;
    }
  }
  register RxPBDlyTg1_r6 @'h669 {
    field RxPBDlyTg1_r6 @0 {
       bits 7;
       access rw;
       reset 7'h0;
    }
  }
  register RxPBDlyTg2_r6 @'h66a {
    field RxPBDlyTg2_r6 @0 {
       bits 7;
       access rw;
       reset 7'h0;
    }
  }
  register RxPBDlyTg3_r6 @'h66b {
    field RxPBDlyTg3_r6 @0 {
       bits 7;
       access rw;
       reset 7'h0;
    }
  }
  register Tsm0_i6 @'h6b2 {
    field RFU_Tsm0_i6 @0 {
       bits 14;
       access rw;
       reset 14'h0;
    }
  }
  register Tsm1_i6 @'h6b3 {
    field RFU_Tsm1_i6 @0 {
       bits 16;
       access ro;
       reset 16'h0;
    }
  }
  register Tsm2_i6 @'h6b4 {
    field RFU_Tsm2_i6 @0 {
       bits 1;
       access rw;
       reset 1'h0;
    }
  }
  register TxDqDlyTg0_r6_p0 @'h6c0 {
    field TxDqDlyTg0_r6_p0 @0 {
       bits 9;
       access rw;
       reset 9'h10;
    }
  }
  register TxDqDlyTg1_r6_p0 @'h6c1 {
    field TxDqDlyTg1_r6_p0 @0 {
       bits 9;
       access rw;
       reset 9'h10;
    }
  }
  register TxDqDlyTg2_r6_p0 @'h6c2 {
    field TxDqDlyTg2_r6_p0 @0 {
       bits 9;
       access rw;
       reset 9'h10;
    }
  }
  register TxDqDlyTg3_r6_p0 @'h6c3 {
    field TxDqDlyTg3_r6_p0 @0 {
       bits 9;
       access rw;
       reset 9'h10;
    }
  }
  register VrefDAC1_r7 @'h730 {
    field VrefDAC1_r7 @0 {
       bits 7;
       access rw;
       reset 7'h0;
    }
  }
  register TrainingCntr_r7 @'h732 {
    field RFU_TrainingCntr_r7 @0 {
       bits 16;
       access rw;
       reset 16'h0;
    }
  }
  register VrefDAC0_r7 @'h740 {
    field VrefDAC0_r7 @0 {
       bits 7;
       access rw;
       reset 7'h0;
    }
  }
  register TrainingIncDecDtsmEn_r7 @'h762 {
    field TrainingIncDecDtsmEn_r7 @0 {
       bits 9;
       access rw;
       reset 9'h0;
    }
  }
  register RxPBDlyTg0_r7 @'h768 {
    field RxPBDlyTg0_r7 @0 {
       bits 7;
       access rw;
       reset 7'h0;
    }
  }
  register RxPBDlyTg1_r7 @'h769 {
    field RxPBDlyTg1_r7 @0 {
       bits 7;
       access rw;
       reset 7'h0;
    }
  }
  register RxPBDlyTg2_r7 @'h76a {
    field RxPBDlyTg2_r7 @0 {
       bits 7;
       access rw;
       reset 7'h0;
    }
  }
  register RxPBDlyTg3_r7 @'h76b {
    field RxPBDlyTg3_r7 @0 {
       bits 7;
       access rw;
       reset 7'h0;
    }
  }
  register Tsm0_i7 @'h7b2 {
    field RFU_Tsm0_i7 @0 {
       bits 14;
       access rw;
       reset 14'h0;
    }
  }
  register Tsm1_i7 @'h7b3 {
    field RFU_Tsm1_i7 @0 {
       bits 16;
       access ro;
       reset 16'h0;
    }
  }
  register Tsm2_i7 @'h7b4 {
    field RFU_Tsm2_i7 @0 {
       bits 1;
       access rw;
       reset 1'h0;
    }
  }
  register TxDqDlyTg0_r7_p0 @'h7c0 {
    field TxDqDlyTg0_r7_p0 @0 {
       bits 9;
       access rw;
       reset 9'h10;
    }
  }
  register TxDqDlyTg1_r7_p0 @'h7c1 {
    field TxDqDlyTg1_r7_p0 @0 {
       bits 9;
       access rw;
       reset 9'h10;
    }
  }
  register TxDqDlyTg2_r7_p0 @'h7c2 {
    field TxDqDlyTg2_r7_p0 @0 {
       bits 9;
       access rw;
       reset 9'h10;
    }
  }
  register TxDqDlyTg3_r7_p0 @'h7c3 {
    field TxDqDlyTg3_r7_p0 @0 {
       bits 9;
       access rw;
       reset 9'h10;
    }
  }
  register VrefDAC1_r8 @'h830 {
    field VrefDAC1_r8 @0 {
       bits 7;
       access rw;
       reset 7'h0;
    }
  }
  register TrainingCntr_r8 @'h832 {
    field RFU_TrainingCntr_r8 @0 {
       bits 16;
       access rw;
       reset 16'h0;
    }
  }
  register VrefDAC0_r8 @'h840 {
    field VrefDAC0_r8 @0 {
       bits 7;
       access rw;
       reset 7'h0;
    }
  }
  register TrainingIncDecDtsmEn_r8 @'h862 {
    field TrainingIncDecDtsmEn_r8 @0 {
       bits 9;
       access rw;
       reset 9'h0;
    }
  }
  register RxPBDlyTg0_r8 @'h868 {
    field RxPBDlyTg0_r8 @0 {
       bits 7;
       access rw;
       reset 7'h0;
    }
  }
  register RxPBDlyTg1_r8 @'h869 {
    field RxPBDlyTg1_r8 @0 {
       bits 7;
       access rw;
       reset 7'h0;
    }
  }
  register RxPBDlyTg2_r8 @'h86a {
    field RxPBDlyTg2_r8 @0 {
       bits 7;
       access rw;
       reset 7'h0;
    }
  }
  register RxPBDlyTg3_r8 @'h86b {
    field RxPBDlyTg3_r8 @0 {
       bits 7;
       access rw;
       reset 7'h0;
    }
  }
  register Tsm0_i8 @'h8b2 {
    field RFU_Tsm0_i8 @0 {
       bits 14;
       access rw;
       reset 14'h0;
    }
  }
  register Tsm1_i8 @'h8b3 {
    field RFU_Tsm1_i8 @0 {
       bits 16;
       access ro;
       reset 16'h0;
    }
  }
  register Tsm2_i8 @'h8b4 {
    field RFU_Tsm2_i8 @0 {
       bits 1;
       access rw;
       reset 1'h0;
    }
  }
  register TxDqDlyTg0_r8_p0 @'h8c0 {
    field TxDqDlyTg0_r8_p0 @0 {
       bits 9;
       access rw;
       reset 9'h10;
    }
  }
  register TxDqDlyTg1_r8_p0 @'h8c1 {
    field TxDqDlyTg1_r8_p0 @0 {
       bits 9;
       access rw;
       reset 9'h10;
    }
  }
  register TxDqDlyTg2_r8_p0 @'h8c2 {
    field TxDqDlyTg2_r8_p0 @0 {
       bits 9;
       access rw;
       reset 9'h10;
    }
  }
  register TxDqDlyTg3_r8_p0 @'h8c3 {
    field TxDqDlyTg3_r8_p0 @0 {
       bits 9;
       access rw;
       reset 9'h10;
    }
  }
  register UseDqsEnReplica_p1 @'h100003 {
    field UseDqsEnReplica_p1 @0 {
       bits 1;
       access rw;
       reset 1'h0;
    }
  }
  register DFIMRL_p1 @'h100020 {
    field DFIMRL_p1 @0 {
       bits 5;
       access rw;
       reset 5'h6;
    }
  }
  register TxImpedanceCtrl0_b0_p1 @'h100041 {
    field DrvStrenDqP @0 {
       bits 6;
       access rw;
       reset 6'h3f;
    }
    field DrvStrenDqN @6 {
       bits 6;
       access rw;
       reset 6'h3f;
    }
  }
  register DqDqsRcvCntrl_b0_p1 @'h100043 {
    field SelAnalogVref @0 {
       bits 1;
       access rw;
       reset 1'h0;
    }
    field ExtVrefRange @1 {
       bits 1;
       access rw;
       reset 1'h0;
    }
    field DfeCtrl @2 {
       bits 2;
       access rw;
       reset 2'h0;
    }
    field MajorModeDbyte @4 {
       bits 3;
       access rw;
       reset 3'h3;
    }
    field GainCurrAdj @7 {
       bits 5;
       access rw;
       reset 5'hb;
    }
    field Reserved @12 {
       bits 4;
    }
  }
  register TxEqualizationMode_p1 @'h100048 {
    field TxEqMode @0 {
       bits 2;
       access rw;
       reset 2'h0;
    }
  }
  register TxImpedanceCtrl1_b0_p1 @'h100049 {
    field DrvStrenFSDqP @0 {
       bits 6;
       access rw;
       reset 6'h3f;
    }
    field DrvStrenFSDqN @6 {
       bits 6;
       access rw;
       reset 6'h3f;
    }
  }
  register TxImpedanceCtrl2_b0_p1 @'h10004b {
    field DrvStrenEQHiDqP @0 {
       bits 6;
       access rw;
       reset 6'h0;
    }
    field DrvStrenEQLoDqN @6 {
       bits 6;
       access rw;
       reset 6'h0;
    }
  }
  register DqDqsRcvCntrl2_p1 @'h10004c {
    field EnRxAgressivePDR @0 {
       bits 1;
       access rw;
       reset 1'h0;
    }
  }
  register TxOdtDrvStren_b0_p1 @'h10004d {
    field ODTStrenP @0 {
       bits 6;
       access rw;
       reset 6'h0;
    }
    field ODTStrenN @6 {
       bits 6;
       access rw;
       reset 6'h0;
    }
  }
  register TxSlewRate_b0_p1 @'h10005f {
    field TxPreP @0 {
       bits 4;
       access rw;
       reset 4'hf;
    }
    field TxPreN @4 {
       bits 4;
       access rw;
       reset 4'hf;
    }
    field TxPreDrvMode @8 {
       bits 3;
       access rw;
       reset 3'h7;
    }
  }
  register RxEnDlyTg0_u0_p1 @'h100080 {
    field RxEnDlyTg0_u0_p1 @0 {
       bits 11;
       access rw;
       reset 11'h100;
    }
  }
  register RxEnDlyTg1_u0_p1 @'h100081 {
    field RxEnDlyTg1_u0_p1 @0 {
       bits 11;
       access rw;
       reset 11'h100;
    }
  }
  register RxEnDlyTg2_u0_p1 @'h100082 {
    field RxEnDlyTg2_u0_p1 @0 {
       bits 11;
       access rw;
       reset 11'h100;
    }
  }
  register RxEnDlyTg3_u0_p1 @'h100083 {
    field RxEnDlyTg3_u0_p1 @0 {
       bits 11;
       access rw;
       reset 11'h100;
    }
  }
  register RxClkDlyTg0_u0_p1 @'h10008c {
    field RxClkDlyTg0_u0_p1 @0 {
       bits 6;
       access rw;
       reset 6'h10;
    }
  }
  register RxClkDlyTg1_u0_p1 @'h10008d {
    field RxClkDlyTg1_u0_p1 @0 {
       bits 6;
       access rw;
       reset 6'h10;
    }
  }
  register RxClkDlyTg2_u0_p1 @'h10008e {
    field RxClkDlyTg2_u0_p1 @0 {
       bits 6;
       access rw;
       reset 6'h10;
    }
  }
  register RxClkDlyTg3_u0_p1 @'h10008f {
    field RxClkDlyTg3_u0_p1 @0 {
       bits 6;
       access rw;
       reset 6'h10;
    }
  }
  register RxClkcDlyTg0_u0_p1 @'h100090 {
    field RxClkcDlyTg0_u0_p1 @0 {
       bits 6;
       access rw;
       reset 6'h10;
    }
  }
  register RxClkcDlyTg1_u0_p1 @'h100091 {
    field RxClkcDlyTg1_u0_p1 @0 {
       bits 6;
       access rw;
       reset 6'h10;
    }
  }
  register RxClkcDlyTg2_u0_p1 @'h100092 {
    field RxClkcDlyTg2_u0_p1 @0 {
       bits 6;
       access rw;
       reset 6'h10;
    }
  }
  register RxClkcDlyTg3_u0_p1 @'h100093 {
    field RxClkcDlyTg3_u0_p1 @0 {
       bits 6;
       access rw;
       reset 6'h10;
    }
  }
  register PptDqsCntInvTrnTg0_p1 @'h1000ae {
    field PptDqsCntInvTrnTg0_p1 @0 {
       bits 16;
       access rw;
       reset 16'h0;
    }
  }
  register PptDqsCntInvTrnTg1_p1 @'h1000af {
    field PptDqsCntInvTrnTg1_p1 @0 {
       bits 16;
       access rw;
       reset 16'h0;
    }
  }
  register TxDqDlyTg0_r0_p1 @'h1000c0 {
    field TxDqDlyTg0_r0_p1 @0 {
       bits 9;
       access rw;
       reset 9'h10;
    }
  }
  register TxDqDlyTg1_r0_p1 @'h1000c1 {
    field TxDqDlyTg1_r0_p1 @0 {
       bits 9;
       access rw;
       reset 9'h10;
    }
  }
  register TxDqDlyTg2_r0_p1 @'h1000c2 {
    field TxDqDlyTg2_r0_p1 @0 {
       bits 9;
       access rw;
       reset 9'h10;
    }
  }
  register TxDqDlyTg3_r0_p1 @'h1000c3 {
    field TxDqDlyTg3_r0_p1 @0 {
       bits 9;
       access rw;
       reset 9'h10;
    }
  }
  register TxDqsDlyTg0_u0_p1 @'h1000d0 {
    field TxDqsDlyTg0_u0_p1 @0 {
       bits 10;
       access rw;
       reset 10'h100;
    }
  }
  register TxDqsDlyTg1_u0_p1 @'h1000d1 {
    field TxDqsDlyTg1_u0_p1 @0 {
       bits 10;
       access rw;
       reset 10'h100;
    }
  }
  register TxDqsDlyTg2_u0_p1 @'h1000d2 {
    field TxDqsDlyTg2_u0_p1 @0 {
       bits 10;
       access rw;
       reset 10'h100;
    }
  }
  register TxDqsDlyTg3_u0_p1 @'h1000d3 {
    field TxDqsDlyTg3_u0_p1 @0 {
       bits 10;
       access rw;
       reset 10'h100;
    }
  }
  register TxImpedanceCtrl0_b1_p1 @'h100141 {
    field DrvStrenDqP @0 {
       bits 6;
       access rw;
       reset 6'h3f;
    }
    field DrvStrenDqN @6 {
       bits 6;
       access rw;
       reset 6'h3f;
    }
  }
  register DqDqsRcvCntrl_b1_p1 @'h100143 {
    field SelAnalogVref @0 {
       bits 1;
       access rw;
       reset 1'h0;
    }
    field ExtVrefRange @1 {
       bits 1;
       access rw;
       reset 1'h0;
    }
    field DfeCtrl @2 {
       bits 2;
       access rw;
       reset 2'h0;
    }
    field MajorModeDbyte @4 {
       bits 3;
       access rw;
       reset 3'h3;
    }
    field GainCurrAdj @7 {
       bits 5;
       access rw;
       reset 5'hb;
    }
    field Reserved @12 {
       bits 4;
    }
  }
  register TxImpedanceCtrl1_b1_p1 @'h100149 {
    field DrvStrenFSDqP @0 {
       bits 6;
       access rw;
       reset 6'h3f;
    }
    field DrvStrenFSDqN @6 {
       bits 6;
       access rw;
       reset 6'h3f;
    }
  }
  register TxImpedanceCtrl2_b1_p1 @'h10014b {
    field DrvStrenEQHiDqP @0 {
       bits 6;
       access rw;
       reset 6'h0;
    }
    field DrvStrenEQLoDqN @6 {
       bits 6;
       access rw;
       reset 6'h0;
    }
  }
  register TxOdtDrvStren_b1_p1 @'h10014d {
    field ODTStrenP @0 {
       bits 6;
       access rw;
       reset 6'h0;
    }
    field ODTStrenN @6 {
       bits 6;
       access rw;
       reset 6'h0;
    }
  }
  register TxSlewRate_b1_p1 @'h10015f {
    field TxPreP @0 {
       bits 4;
       access rw;
       reset 4'hf;
    }
    field TxPreN @4 {
       bits 4;
       access rw;
       reset 4'hf;
    }
    field TxPreDrvMode @8 {
       bits 3;
       access rw;
       reset 3'h7;
    }
  }
  register RxEnDlyTg0_u1_p1 @'h100180 {
    field RxEnDlyTg0_u1_p1 @0 {
       bits 11;
       access rw;
       reset 11'h100;
    }
  }
  register RxEnDlyTg1_u1_p1 @'h100181 {
    field RxEnDlyTg1_u1_p1 @0 {
       bits 11;
       access rw;
       reset 11'h100;
    }
  }
  register RxEnDlyTg2_u1_p1 @'h100182 {
    field RxEnDlyTg2_u1_p1 @0 {
       bits 11;
       access rw;
       reset 11'h100;
    }
  }
  register RxEnDlyTg3_u1_p1 @'h100183 {
    field RxEnDlyTg3_u1_p1 @0 {
       bits 11;
       access rw;
       reset 11'h100;
    }
  }
  register RxClkDlyTg0_u1_p1 @'h10018c {
    field RxClkDlyTg0_u1_p1 @0 {
       bits 6;
       access rw;
       reset 6'h10;
    }
  }
  register RxClkDlyTg1_u1_p1 @'h10018d {
    field RxClkDlyTg1_u1_p1 @0 {
       bits 6;
       access rw;
       reset 6'h10;
    }
  }
  register RxClkDlyTg2_u1_p1 @'h10018e {
    field RxClkDlyTg2_u1_p1 @0 {
       bits 6;
       access rw;
       reset 6'h10;
    }
  }
  register RxClkDlyTg3_u1_p1 @'h10018f {
    field RxClkDlyTg3_u1_p1 @0 {
       bits 6;
       access rw;
       reset 6'h10;
    }
  }
  register RxClkcDlyTg0_u1_p1 @'h100190 {
    field RxClkcDlyTg0_u1_p1 @0 {
       bits 6;
       access rw;
       reset 6'h10;
    }
  }
  register RxClkcDlyTg1_u1_p1 @'h100191 {
    field RxClkcDlyTg1_u1_p1 @0 {
       bits 6;
       access rw;
       reset 6'h10;
    }
  }
  register RxClkcDlyTg2_u1_p1 @'h100192 {
    field RxClkcDlyTg2_u1_p1 @0 {
       bits 6;
       access rw;
       reset 6'h10;
    }
  }
  register RxClkcDlyTg3_u1_p1 @'h100193 {
    field RxClkcDlyTg3_u1_p1 @0 {
       bits 6;
       access rw;
       reset 6'h10;
    }
  }
  register TxDqDlyTg0_r1_p1 @'h1001c0 {
    field TxDqDlyTg0_r1_p1 @0 {
       bits 9;
       access rw;
       reset 9'h10;
    }
  }
  register TxDqDlyTg1_r1_p1 @'h1001c1 {
    field TxDqDlyTg1_r1_p1 @0 {
       bits 9;
       access rw;
       reset 9'h10;
    }
  }
  register TxDqDlyTg2_r1_p1 @'h1001c2 {
    field TxDqDlyTg2_r1_p1 @0 {
       bits 9;
       access rw;
       reset 9'h10;
    }
  }
  register TxDqDlyTg3_r1_p1 @'h1001c3 {
    field TxDqDlyTg3_r1_p1 @0 {
       bits 9;
       access rw;
       reset 9'h10;
    }
  }
  register TxDqsDlyTg0_u1_p1 @'h1001d0 {
    field TxDqsDlyTg0_u1_p1 @0 {
       bits 10;
       access rw;
       reset 10'h100;
    }
  }
  register TxDqsDlyTg1_u1_p1 @'h1001d1 {
    field TxDqsDlyTg1_u1_p1 @0 {
       bits 10;
       access rw;
       reset 10'h100;
    }
  }
  register TxDqsDlyTg2_u1_p1 @'h1001d2 {
    field TxDqsDlyTg2_u1_p1 @0 {
       bits 10;
       access rw;
       reset 10'h100;
    }
  }
  register TxDqsDlyTg3_u1_p1 @'h1001d3 {
    field TxDqsDlyTg3_u1_p1 @0 {
       bits 10;
       access rw;
       reset 10'h100;
    }
  }
  register TxDqDlyTg0_r2_p1 @'h1002c0 {
    field TxDqDlyTg0_r2_p1 @0 {
       bits 9;
       access rw;
       reset 9'h10;
    }
  }
  register TxDqDlyTg1_r2_p1 @'h1002c1 {
    field TxDqDlyTg1_r2_p1 @0 {
       bits 9;
       access rw;
       reset 9'h10;
    }
  }
  register TxDqDlyTg2_r2_p1 @'h1002c2 {
    field TxDqDlyTg2_r2_p1 @0 {
       bits 9;
       access rw;
       reset 9'h10;
    }
  }
  register TxDqDlyTg3_r2_p1 @'h1002c3 {
    field TxDqDlyTg3_r2_p1 @0 {
       bits 9;
       access rw;
       reset 9'h10;
    }
  }
  register TxDqDlyTg0_r3_p1 @'h1003c0 {
    field TxDqDlyTg0_r3_p1 @0 {
       bits 9;
       access rw;
       reset 9'h10;
    }
  }
  register TxDqDlyTg1_r3_p1 @'h1003c1 {
    field TxDqDlyTg1_r3_p1 @0 {
       bits 9;
       access rw;
       reset 9'h10;
    }
  }
  register TxDqDlyTg2_r3_p1 @'h1003c2 {
    field TxDqDlyTg2_r3_p1 @0 {
       bits 9;
       access rw;
       reset 9'h10;
    }
  }
  register TxDqDlyTg3_r3_p1 @'h1003c3 {
    field TxDqDlyTg3_r3_p1 @0 {
       bits 9;
       access rw;
       reset 9'h10;
    }
  }
  register TxDqDlyTg0_r4_p1 @'h1004c0 {
    field TxDqDlyTg0_r4_p1 @0 {
       bits 9;
       access rw;
       reset 9'h10;
    }
  }
  register TxDqDlyTg1_r4_p1 @'h1004c1 {
    field TxDqDlyTg1_r4_p1 @0 {
       bits 9;
       access rw;
       reset 9'h10;
    }
  }
  register TxDqDlyTg2_r4_p1 @'h1004c2 {
    field TxDqDlyTg2_r4_p1 @0 {
       bits 9;
       access rw;
       reset 9'h10;
    }
  }
  register TxDqDlyTg3_r4_p1 @'h1004c3 {
    field TxDqDlyTg3_r4_p1 @0 {
       bits 9;
       access rw;
       reset 9'h10;
    }
  }
  register TxDqDlyTg0_r5_p1 @'h1005c0 {
    field TxDqDlyTg0_r5_p1 @0 {
       bits 9;
       access rw;
       reset 9'h10;
    }
  }
  register TxDqDlyTg1_r5_p1 @'h1005c1 {
    field TxDqDlyTg1_r5_p1 @0 {
       bits 9;
       access rw;
       reset 9'h10;
    }
  }
  register TxDqDlyTg2_r5_p1 @'h1005c2 {
    field TxDqDlyTg2_r5_p1 @0 {
       bits 9;
       access rw;
       reset 9'h10;
    }
  }
  register TxDqDlyTg3_r5_p1 @'h1005c3 {
    field TxDqDlyTg3_r5_p1 @0 {
       bits 9;
       access rw;
       reset 9'h10;
    }
  }
  register TxDqDlyTg0_r6_p1 @'h1006c0 {
    field TxDqDlyTg0_r6_p1 @0 {
       bits 9;
       access rw;
       reset 9'h10;
    }
  }
  register TxDqDlyTg1_r6_p1 @'h1006c1 {
    field TxDqDlyTg1_r6_p1 @0 {
       bits 9;
       access rw;
       reset 9'h10;
    }
  }
  register TxDqDlyTg2_r6_p1 @'h1006c2 {
    field TxDqDlyTg2_r6_p1 @0 {
       bits 9;
       access rw;
       reset 9'h10;
    }
  }
  register TxDqDlyTg3_r6_p1 @'h1006c3 {
    field TxDqDlyTg3_r6_p1 @0 {
       bits 9;
       access rw;
       reset 9'h10;
    }
  }
  register TxDqDlyTg0_r7_p1 @'h1007c0 {
    field TxDqDlyTg0_r7_p1 @0 {
       bits 9;
       access rw;
       reset 9'h10;
    }
  }
  register TxDqDlyTg1_r7_p1 @'h1007c1 {
    field TxDqDlyTg1_r7_p1 @0 {
       bits 9;
       access rw;
       reset 9'h10;
    }
  }
  register TxDqDlyTg2_r7_p1 @'h1007c2 {
    field TxDqDlyTg2_r7_p1 @0 {
       bits 9;
       access rw;
       reset 9'h10;
    }
  }
  register TxDqDlyTg3_r7_p1 @'h1007c3 {
    field TxDqDlyTg3_r7_p1 @0 {
       bits 9;
       access rw;
       reset 9'h10;
    }
  }
  register TxDqDlyTg0_r8_p1 @'h1008c0 {
    field TxDqDlyTg0_r8_p1 @0 {
       bits 9;
       access rw;
       reset 9'h10;
    }
  }
  register TxDqDlyTg1_r8_p1 @'h1008c1 {
    field TxDqDlyTg1_r8_p1 @0 {
       bits 9;
       access rw;
       reset 9'h10;
    }
  }
  register TxDqDlyTg2_r8_p1 @'h1008c2 {
    field TxDqDlyTg2_r8_p1 @0 {
       bits 9;
       access rw;
       reset 9'h10;
    }
  }
  register TxDqDlyTg3_r8_p1 @'h1008c3 {
    field TxDqDlyTg3_r8_p1 @0 {
       bits 9;
       access rw;
       reset 9'h10;
    }
  }
  register UseDqsEnReplica_p2 @'h200003 {
    field UseDqsEnReplica_p2 @0 {
       bits 1;
       access rw;
       reset 1'h0;
    }
  }
  register DFIMRL_p2 @'h200020 {
    field DFIMRL_p2 @0 {
       bits 5;
       access rw;
       reset 5'h6;
    }
  }
  register TxImpedanceCtrl0_b0_p2 @'h200041 {
    field DrvStrenDqP @0 {
       bits 6;
       access rw;
       reset 6'h3f;
    }
    field DrvStrenDqN @6 {
       bits 6;
       access rw;
       reset 6'h3f;
    }
  }
  register DqDqsRcvCntrl_b0_p2 @'h200043 {
    field SelAnalogVref @0 {
       bits 1;
       access rw;
       reset 1'h0;
    }
    field ExtVrefRange @1 {
       bits 1;
       access rw;
       reset 1'h0;
    }
    field DfeCtrl @2 {
       bits 2;
       access rw;
       reset 2'h0;
    }
    field MajorModeDbyte @4 {
       bits 3;
       access rw;
       reset 3'h3;
    }
    field GainCurrAdj @7 {
       bits 5;
       access rw;
       reset 5'hb;
    }
    field Reserved @12 {
       bits 4;
    }
  }
  register TxEqualizationMode_p2 @'h200048 {
    field TxEqMode @0 {
       bits 2;
       access rw;
       reset 2'h0;
    }
  }
  register TxImpedanceCtrl1_b0_p2 @'h200049 {
    field DrvStrenFSDqP @0 {
       bits 6;
       access rw;
       reset 6'h3f;
    }
    field DrvStrenFSDqN @6 {
       bits 6;
       access rw;
       reset 6'h3f;
    }
  }
  register TxImpedanceCtrl2_b0_p2 @'h20004b {
    field DrvStrenEQHiDqP @0 {
       bits 6;
       access rw;
       reset 6'h0;
    }
    field DrvStrenEQLoDqN @6 {
       bits 6;
       access rw;
       reset 6'h0;
    }
  }
  register DqDqsRcvCntrl2_p2 @'h20004c {
    field EnRxAgressivePDR @0 {
       bits 1;
       access rw;
       reset 1'h0;
    }
  }
  register TxOdtDrvStren_b0_p2 @'h20004d {
    field ODTStrenP @0 {
       bits 6;
       access rw;
       reset 6'h0;
    }
    field ODTStrenN @6 {
       bits 6;
       access rw;
       reset 6'h0;
    }
  }
  register TxSlewRate_b0_p2 @'h20005f {
    field TxPreP @0 {
       bits 4;
       access rw;
       reset 4'hf;
    }
    field TxPreN @4 {
       bits 4;
       access rw;
       reset 4'hf;
    }
    field TxPreDrvMode @8 {
       bits 3;
       access rw;
       reset 3'h7;
    }
  }
  register RxEnDlyTg0_u0_p2 @'h200080 {
    field RxEnDlyTg0_u0_p2 @0 {
       bits 11;
       access rw;
       reset 11'h100;
    }
  }
  register RxEnDlyTg1_u0_p2 @'h200081 {
    field RxEnDlyTg1_u0_p2 @0 {
       bits 11;
       access rw;
       reset 11'h100;
    }
  }
  register RxEnDlyTg2_u0_p2 @'h200082 {
    field RxEnDlyTg2_u0_p2 @0 {
       bits 11;
       access rw;
       reset 11'h100;
    }
  }
  register RxEnDlyTg3_u0_p2 @'h200083 {
    field RxEnDlyTg3_u0_p2 @0 {
       bits 11;
       access rw;
       reset 11'h100;
    }
  }
  register RxClkDlyTg0_u0_p2 @'h20008c {
    field RxClkDlyTg0_u0_p2 @0 {
       bits 6;
       access rw;
       reset 6'h10;
    }
  }
  register RxClkDlyTg1_u0_p2 @'h20008d {
    field RxClkDlyTg1_u0_p2 @0 {
       bits 6;
       access rw;
       reset 6'h10;
    }
  }
  register RxClkDlyTg2_u0_p2 @'h20008e {
    field RxClkDlyTg2_u0_p2 @0 {
       bits 6;
       access rw;
       reset 6'h10;
    }
  }
  register RxClkDlyTg3_u0_p2 @'h20008f {
    field RxClkDlyTg3_u0_p2 @0 {
       bits 6;
       access rw;
       reset 6'h10;
    }
  }
  register RxClkcDlyTg0_u0_p2 @'h200090 {
    field RxClkcDlyTg0_u0_p2 @0 {
       bits 6;
       access rw;
       reset 6'h10;
    }
  }
  register RxClkcDlyTg1_u0_p2 @'h200091 {
    field RxClkcDlyTg1_u0_p2 @0 {
       bits 6;
       access rw;
       reset 6'h10;
    }
  }
  register RxClkcDlyTg2_u0_p2 @'h200092 {
    field RxClkcDlyTg2_u0_p2 @0 {
       bits 6;
       access rw;
       reset 6'h10;
    }
  }
  register RxClkcDlyTg3_u0_p2 @'h200093 {
    field RxClkcDlyTg3_u0_p2 @0 {
       bits 6;
       access rw;
       reset 6'h10;
    }
  }
  register PptDqsCntInvTrnTg0_p2 @'h2000ae {
    field PptDqsCntInvTrnTg0_p2 @0 {
       bits 16;
       access rw;
       reset 16'h0;
    }
  }
  register PptDqsCntInvTrnTg1_p2 @'h2000af {
    field PptDqsCntInvTrnTg1_p2 @0 {
       bits 16;
       access rw;
       reset 16'h0;
    }
  }
  register TxDqDlyTg0_r0_p2 @'h2000c0 {
    field TxDqDlyTg0_r0_p2 @0 {
       bits 9;
       access rw;
       reset 9'h10;
    }
  }
  register TxDqDlyTg1_r0_p2 @'h2000c1 {
    field TxDqDlyTg1_r0_p2 @0 {
       bits 9;
       access rw;
       reset 9'h10;
    }
  }
  register TxDqDlyTg2_r0_p2 @'h2000c2 {
    field TxDqDlyTg2_r0_p2 @0 {
       bits 9;
       access rw;
       reset 9'h10;
    }
  }
  register TxDqDlyTg3_r0_p2 @'h2000c3 {
    field TxDqDlyTg3_r0_p2 @0 {
       bits 9;
       access rw;
       reset 9'h10;
    }
  }
  register TxDqsDlyTg0_u0_p2 @'h2000d0 {
    field TxDqsDlyTg0_u0_p2 @0 {
       bits 10;
       access rw;
       reset 10'h100;
    }
  }
  register TxDqsDlyTg1_u0_p2 @'h2000d1 {
    field TxDqsDlyTg1_u0_p2 @0 {
       bits 10;
       access rw;
       reset 10'h100;
    }
  }
  register TxDqsDlyTg2_u0_p2 @'h2000d2 {
    field TxDqsDlyTg2_u0_p2 @0 {
       bits 10;
       access rw;
       reset 10'h100;
    }
  }
  register TxDqsDlyTg3_u0_p2 @'h2000d3 {
    field TxDqsDlyTg3_u0_p2 @0 {
       bits 10;
       access rw;
       reset 10'h100;
    }
  }
  register TxImpedanceCtrl0_b1_p2 @'h200141 {
    field DrvStrenDqP @0 {
       bits 6;
       access rw;
       reset 6'h3f;
    }
    field DrvStrenDqN @6 {
       bits 6;
       access rw;
       reset 6'h3f;
    }
  }
  register DqDqsRcvCntrl_b1_p2 @'h200143 {
    field SelAnalogVref @0 {
       bits 1;
       access rw;
       reset 1'h0;
    }
    field ExtVrefRange @1 {
       bits 1;
       access rw;
       reset 1'h0;
    }
    field DfeCtrl @2 {
       bits 2;
       access rw;
       reset 2'h0;
    }
    field MajorModeDbyte @4 {
       bits 3;
       access rw;
       reset 3'h3;
    }
    field GainCurrAdj @7 {
       bits 5;
       access rw;
       reset 5'hb;
    }
    field Reserved @12 {
       bits 4;
    }
  }
  register TxImpedanceCtrl1_b1_p2 @'h200149 {
    field DrvStrenFSDqP @0 {
       bits 6;
       access rw;
       reset 6'h3f;
    }
    field DrvStrenFSDqN @6 {
       bits 6;
       access rw;
       reset 6'h3f;
    }
  }
  register TxImpedanceCtrl2_b1_p2 @'h20014b {
    field DrvStrenEQHiDqP @0 {
       bits 6;
       access rw;
       reset 6'h0;
    }
    field DrvStrenEQLoDqN @6 {
       bits 6;
       access rw;
       reset 6'h0;
    }
  }
  register TxOdtDrvStren_b1_p2 @'h20014d {
    field ODTStrenP @0 {
       bits 6;
       access rw;
       reset 6'h0;
    }
    field ODTStrenN @6 {
       bits 6;
       access rw;
       reset 6'h0;
    }
  }
  register TxSlewRate_b1_p2 @'h20015f {
    field TxPreP @0 {
       bits 4;
       access rw;
       reset 4'hf;
    }
    field TxPreN @4 {
       bits 4;
       access rw;
       reset 4'hf;
    }
    field TxPreDrvMode @8 {
       bits 3;
       access rw;
       reset 3'h7;
    }
  }
  register RxEnDlyTg0_u1_p2 @'h200180 {
    field RxEnDlyTg0_u1_p2 @0 {
       bits 11;
       access rw;
       reset 11'h100;
    }
  }
  register RxEnDlyTg1_u1_p2 @'h200181 {
    field RxEnDlyTg1_u1_p2 @0 {
       bits 11;
       access rw;
       reset 11'h100;
    }
  }
  register RxEnDlyTg2_u1_p2 @'h200182 {
    field RxEnDlyTg2_u1_p2 @0 {
       bits 11;
       access rw;
       reset 11'h100;
    }
  }
  register RxEnDlyTg3_u1_p2 @'h200183 {
    field RxEnDlyTg3_u1_p2 @0 {
       bits 11;
       access rw;
       reset 11'h100;
    }
  }
  register RxClkDlyTg0_u1_p2 @'h20018c {
    field RxClkDlyTg0_u1_p2 @0 {
       bits 6;
       access rw;
       reset 6'h10;
    }
  }
  register RxClkDlyTg1_u1_p2 @'h20018d {
    field RxClkDlyTg1_u1_p2 @0 {
       bits 6;
       access rw;
       reset 6'h10;
    }
  }
  register RxClkDlyTg2_u1_p2 @'h20018e {
    field RxClkDlyTg2_u1_p2 @0 {
       bits 6;
       access rw;
       reset 6'h10;
    }
  }
  register RxClkDlyTg3_u1_p2 @'h20018f {
    field RxClkDlyTg3_u1_p2 @0 {
       bits 6;
       access rw;
       reset 6'h10;
    }
  }
  register RxClkcDlyTg0_u1_p2 @'h200190 {
    field RxClkcDlyTg0_u1_p2 @0 {
       bits 6;
       access rw;
       reset 6'h10;
    }
  }
  register RxClkcDlyTg1_u1_p2 @'h200191 {
    field RxClkcDlyTg1_u1_p2 @0 {
       bits 6;
       access rw;
       reset 6'h10;
    }
  }
  register RxClkcDlyTg2_u1_p2 @'h200192 {
    field RxClkcDlyTg2_u1_p2 @0 {
       bits 6;
       access rw;
       reset 6'h10;
    }
  }
  register RxClkcDlyTg3_u1_p2 @'h200193 {
    field RxClkcDlyTg3_u1_p2 @0 {
       bits 6;
       access rw;
       reset 6'h10;
    }
  }
  register TxDqDlyTg0_r1_p2 @'h2001c0 {
    field TxDqDlyTg0_r1_p2 @0 {
       bits 9;
       access rw;
       reset 9'h10;
    }
  }
  register TxDqDlyTg1_r1_p2 @'h2001c1 {
    field TxDqDlyTg1_r1_p2 @0 {
       bits 9;
       access rw;
       reset 9'h10;
    }
  }
  register TxDqDlyTg2_r1_p2 @'h2001c2 {
    field TxDqDlyTg2_r1_p2 @0 {
       bits 9;
       access rw;
       reset 9'h10;
    }
  }
  register TxDqDlyTg3_r1_p2 @'h2001c3 {
    field TxDqDlyTg3_r1_p2 @0 {
       bits 9;
       access rw;
       reset 9'h10;
    }
  }
  register TxDqsDlyTg0_u1_p2 @'h2001d0 {
    field TxDqsDlyTg0_u1_p2 @0 {
       bits 10;
       access rw;
       reset 10'h100;
    }
  }
  register TxDqsDlyTg1_u1_p2 @'h2001d1 {
    field TxDqsDlyTg1_u1_p2 @0 {
       bits 10;
       access rw;
       reset 10'h100;
    }
  }
  register TxDqsDlyTg2_u1_p2 @'h2001d2 {
    field TxDqsDlyTg2_u1_p2 @0 {
       bits 10;
       access rw;
       reset 10'h100;
    }
  }
  register TxDqsDlyTg3_u1_p2 @'h2001d3 {
    field TxDqsDlyTg3_u1_p2 @0 {
       bits 10;
       access rw;
       reset 10'h100;
    }
  }
  register TxDqDlyTg0_r2_p2 @'h2002c0 {
    field TxDqDlyTg0_r2_p2 @0 {
       bits 9;
       access rw;
       reset 9'h10;
    }
  }
  register TxDqDlyTg1_r2_p2 @'h2002c1 {
    field TxDqDlyTg1_r2_p2 @0 {
       bits 9;
       access rw;
       reset 9'h10;
    }
  }
  register TxDqDlyTg2_r2_p2 @'h2002c2 {
    field TxDqDlyTg2_r2_p2 @0 {
       bits 9;
       access rw;
       reset 9'h10;
    }
  }
  register TxDqDlyTg3_r2_p2 @'h2002c3 {
    field TxDqDlyTg3_r2_p2 @0 {
       bits 9;
       access rw;
       reset 9'h10;
    }
  }
  register TxDqDlyTg0_r3_p2 @'h2003c0 {
    field TxDqDlyTg0_r3_p2 @0 {
       bits 9;
       access rw;
       reset 9'h10;
    }
  }
  register TxDqDlyTg1_r3_p2 @'h2003c1 {
    field TxDqDlyTg1_r3_p2 @0 {
       bits 9;
       access rw;
       reset 9'h10;
    }
  }
  register TxDqDlyTg2_r3_p2 @'h2003c2 {
    field TxDqDlyTg2_r3_p2 @0 {
       bits 9;
       access rw;
       reset 9'h10;
    }
  }
  register TxDqDlyTg3_r3_p2 @'h2003c3 {
    field TxDqDlyTg3_r3_p2 @0 {
       bits 9;
       access rw;
       reset 9'h10;
    }
  }
  register TxDqDlyTg0_r4_p2 @'h2004c0 {
    field TxDqDlyTg0_r4_p2 @0 {
       bits 9;
       access rw;
       reset 9'h10;
    }
  }
  register TxDqDlyTg1_r4_p2 @'h2004c1 {
    field TxDqDlyTg1_r4_p2 @0 {
       bits 9;
       access rw;
       reset 9'h10;
    }
  }
  register TxDqDlyTg2_r4_p2 @'h2004c2 {
    field TxDqDlyTg2_r4_p2 @0 {
       bits 9;
       access rw;
       reset 9'h10;
    }
  }
  register TxDqDlyTg3_r4_p2 @'h2004c3 {
    field TxDqDlyTg3_r4_p2 @0 {
       bits 9;
       access rw;
       reset 9'h10;
    }
  }
  register TxDqDlyTg0_r5_p2 @'h2005c0 {
    field TxDqDlyTg0_r5_p2 @0 {
       bits 9;
       access rw;
       reset 9'h10;
    }
  }
  register TxDqDlyTg1_r5_p2 @'h2005c1 {
    field TxDqDlyTg1_r5_p2 @0 {
       bits 9;
       access rw;
       reset 9'h10;
    }
  }
  register TxDqDlyTg2_r5_p2 @'h2005c2 {
    field TxDqDlyTg2_r5_p2 @0 {
       bits 9;
       access rw;
       reset 9'h10;
    }
  }
  register TxDqDlyTg3_r5_p2 @'h2005c3 {
    field TxDqDlyTg3_r5_p2 @0 {
       bits 9;
       access rw;
       reset 9'h10;
    }
  }
  register TxDqDlyTg0_r6_p2 @'h2006c0 {
    field TxDqDlyTg0_r6_p2 @0 {
       bits 9;
       access rw;
       reset 9'h10;
    }
  }
  register TxDqDlyTg1_r6_p2 @'h2006c1 {
    field TxDqDlyTg1_r6_p2 @0 {
       bits 9;
       access rw;
       reset 9'h10;
    }
  }
  register TxDqDlyTg2_r6_p2 @'h2006c2 {
    field TxDqDlyTg2_r6_p2 @0 {
       bits 9;
       access rw;
       reset 9'h10;
    }
  }
  register TxDqDlyTg3_r6_p2 @'h2006c3 {
    field TxDqDlyTg3_r6_p2 @0 {
       bits 9;
       access rw;
       reset 9'h10;
    }
  }
  register TxDqDlyTg0_r7_p2 @'h2007c0 {
    field TxDqDlyTg0_r7_p2 @0 {
       bits 9;
       access rw;
       reset 9'h10;
    }
  }
  register TxDqDlyTg1_r7_p2 @'h2007c1 {
    field TxDqDlyTg1_r7_p2 @0 {
       bits 9;
       access rw;
       reset 9'h10;
    }
  }
  register TxDqDlyTg2_r7_p2 @'h2007c2 {
    field TxDqDlyTg2_r7_p2 @0 {
       bits 9;
       access rw;
       reset 9'h10;
    }
  }
  register TxDqDlyTg3_r7_p2 @'h2007c3 {
    field TxDqDlyTg3_r7_p2 @0 {
       bits 9;
       access rw;
       reset 9'h10;
    }
  }
  register TxDqDlyTg0_r8_p2 @'h2008c0 {
    field TxDqDlyTg0_r8_p2 @0 {
       bits 9;
       access rw;
       reset 9'h10;
    }
  }
  register TxDqDlyTg1_r8_p2 @'h2008c1 {
    field TxDqDlyTg1_r8_p2 @0 {
       bits 9;
       access rw;
       reset 9'h10;
    }
  }
  register TxDqDlyTg2_r8_p2 @'h2008c2 {
    field TxDqDlyTg2_r8_p2 @0 {
       bits 9;
       access rw;
       reset 9'h10;
    }
  }
  register TxDqDlyTg3_r8_p2 @'h2008c3 {
    field TxDqDlyTg3_r8_p2 @0 {
       bits 9;
       access rw;
       reset 9'h10;
    }
  }
  register UseDqsEnReplica_p3 @'h300003 {
    field UseDqsEnReplica_p3 @0 {
       bits 1;
       access rw;
       reset 1'h0;
    }
  }
  register DFIMRL_p3 @'h300020 {
    field DFIMRL_p3 @0 {
       bits 5;
       access rw;
       reset 5'h6;
    }
  }
  register TxImpedanceCtrl0_b0_p3 @'h300041 {
    field DrvStrenDqP @0 {
       bits 6;
       access rw;
       reset 6'h3f;
    }
    field DrvStrenDqN @6 {
       bits 6;
       access rw;
       reset 6'h3f;
    }
  }
  register DqDqsRcvCntrl_b0_p3 @'h300043 {
    field SelAnalogVref @0 {
       bits 1;
       access rw;
       reset 1'h0;
    }
    field ExtVrefRange @1 {
       bits 1;
       access rw;
       reset 1'h0;
    }
    field DfeCtrl @2 {
       bits 2;
       access rw;
       reset 2'h0;
    }
    field MajorModeDbyte @4 {
       bits 3;
       access rw;
       reset 3'h3;
    }
    field GainCurrAdj @7 {
       bits 5;
       access rw;
       reset 5'hb;
    }
    field Reserved @12 {
       bits 4;
    }
  }
  register TxEqualizationMode_p3 @'h300048 {
    field TxEqMode @0 {
       bits 2;
       access rw;
       reset 2'h0;
    }
  }
  register TxImpedanceCtrl1_b0_p3 @'h300049 {
    field DrvStrenFSDqP @0 {
       bits 6;
       access rw;
       reset 6'h3f;
    }
    field DrvStrenFSDqN @6 {
       bits 6;
       access rw;
       reset 6'h3f;
    }
  }
  register TxImpedanceCtrl2_b0_p3 @'h30004b {
    field DrvStrenEQHiDqP @0 {
       bits 6;
       access rw;
       reset 6'h0;
    }
    field DrvStrenEQLoDqN @6 {
       bits 6;
       access rw;
       reset 6'h0;
    }
  }
  register DqDqsRcvCntrl2_p3 @'h30004c {
    field EnRxAgressivePDR @0 {
       bits 1;
       access rw;
       reset 1'h0;
    }
  }
  register TxOdtDrvStren_b0_p3 @'h30004d {
    field ODTStrenP @0 {
       bits 6;
       access rw;
       reset 6'h0;
    }
    field ODTStrenN @6 {
       bits 6;
       access rw;
       reset 6'h0;
    }
  }
  register TxSlewRate_b0_p3 @'h30005f {
    field TxPreP @0 {
       bits 4;
       access rw;
       reset 4'hf;
    }
    field TxPreN @4 {
       bits 4;
       access rw;
       reset 4'hf;
    }
    field TxPreDrvMode @8 {
       bits 3;
       access rw;
       reset 3'h7;
    }
  }
  register RxEnDlyTg0_u0_p3 @'h300080 {
    field RxEnDlyTg0_u0_p3 @0 {
       bits 11;
       access rw;
       reset 11'h100;
    }
  }
  register RxEnDlyTg1_u0_p3 @'h300081 {
    field RxEnDlyTg1_u0_p3 @0 {
       bits 11;
       access rw;
       reset 11'h100;
    }
  }
  register RxEnDlyTg2_u0_p3 @'h300082 {
    field RxEnDlyTg2_u0_p3 @0 {
       bits 11;
       access rw;
       reset 11'h100;
    }
  }
  register RxEnDlyTg3_u0_p3 @'h300083 {
    field RxEnDlyTg3_u0_p3 @0 {
       bits 11;
       access rw;
       reset 11'h100;
    }
  }
  register RxClkDlyTg0_u0_p3 @'h30008c {
    field RxClkDlyTg0_u0_p3 @0 {
       bits 6;
       access rw;
       reset 6'h10;
    }
  }
  register RxClkDlyTg1_u0_p3 @'h30008d {
    field RxClkDlyTg1_u0_p3 @0 {
       bits 6;
       access rw;
       reset 6'h10;
    }
  }
  register RxClkDlyTg2_u0_p3 @'h30008e {
    field RxClkDlyTg2_u0_p3 @0 {
       bits 6;
       access rw;
       reset 6'h10;
    }
  }
  register RxClkDlyTg3_u0_p3 @'h30008f {
    field RxClkDlyTg3_u0_p3 @0 {
       bits 6;
       access rw;
       reset 6'h10;
    }
  }
  register RxClkcDlyTg0_u0_p3 @'h300090 {
    field RxClkcDlyTg0_u0_p3 @0 {
       bits 6;
       access rw;
       reset 6'h10;
    }
  }
  register RxClkcDlyTg1_u0_p3 @'h300091 {
    field RxClkcDlyTg1_u0_p3 @0 {
       bits 6;
       access rw;
       reset 6'h10;
    }
  }
  register RxClkcDlyTg2_u0_p3 @'h300092 {
    field RxClkcDlyTg2_u0_p3 @0 {
       bits 6;
       access rw;
       reset 6'h10;
    }
  }
  register RxClkcDlyTg3_u0_p3 @'h300093 {
    field RxClkcDlyTg3_u0_p3 @0 {
       bits 6;
       access rw;
       reset 6'h10;
    }
  }
  register PptDqsCntInvTrnTg0_p3 @'h3000ae {
    field PptDqsCntInvTrnTg0_p3 @0 {
       bits 16;
       access rw;
       reset 16'h0;
    }
  }
  register PptDqsCntInvTrnTg1_p3 @'h3000af {
    field PptDqsCntInvTrnTg1_p3 @0 {
       bits 16;
       access rw;
       reset 16'h0;
    }
  }
  register TxDqDlyTg0_r0_p3 @'h3000c0 {
    field TxDqDlyTg0_r0_p3 @0 {
       bits 9;
       access rw;
       reset 9'h10;
    }
  }
  register TxDqDlyTg1_r0_p3 @'h3000c1 {
    field TxDqDlyTg1_r0_p3 @0 {
       bits 9;
       access rw;
       reset 9'h10;
    }
  }
  register TxDqDlyTg2_r0_p3 @'h3000c2 {
    field TxDqDlyTg2_r0_p3 @0 {
       bits 9;
       access rw;
       reset 9'h10;
    }
  }
  register TxDqDlyTg3_r0_p3 @'h3000c3 {
    field TxDqDlyTg3_r0_p3 @0 {
       bits 9;
       access rw;
       reset 9'h10;
    }
  }
  register TxDqsDlyTg0_u0_p3 @'h3000d0 {
    field TxDqsDlyTg0_u0_p3 @0 {
       bits 10;
       access rw;
       reset 10'h100;
    }
  }
  register TxDqsDlyTg1_u0_p3 @'h3000d1 {
    field TxDqsDlyTg1_u0_p3 @0 {
       bits 10;
       access rw;
       reset 10'h100;
    }
  }
  register TxDqsDlyTg2_u0_p3 @'h3000d2 {
    field TxDqsDlyTg2_u0_p3 @0 {
       bits 10;
       access rw;
       reset 10'h100;
    }
  }
  register TxDqsDlyTg3_u0_p3 @'h3000d3 {
    field TxDqsDlyTg3_u0_p3 @0 {
       bits 10;
       access rw;
       reset 10'h100;
    }
  }
  register TxImpedanceCtrl0_b1_p3 @'h300141 {
    field DrvStrenDqP @0 {
       bits 6;
       access rw;
       reset 6'h3f;
    }
    field DrvStrenDqN @6 {
       bits 6;
       access rw;
       reset 6'h3f;
    }
  }
  register DqDqsRcvCntrl_b1_p3 @'h300143 {
    field SelAnalogVref @0 {
       bits 1;
       access rw;
       reset 1'h0;
    }
    field ExtVrefRange @1 {
       bits 1;
       access rw;
       reset 1'h0;
    }
    field DfeCtrl @2 {
       bits 2;
       access rw;
       reset 2'h0;
    }
    field MajorModeDbyte @4 {
       bits 3;
       access rw;
       reset 3'h3;
    }
    field GainCurrAdj @7 {
       bits 5;
       access rw;
       reset 5'hb;
    }
    field Reserved @12 {
       bits 4;
    }
  }
  register TxImpedanceCtrl1_b1_p3 @'h300149 {
    field DrvStrenFSDqP @0 {
       bits 6;
       access rw;
       reset 6'h3f;
    }
    field DrvStrenFSDqN @6 {
       bits 6;
       access rw;
       reset 6'h3f;
    }
  }
  register TxImpedanceCtrl2_b1_p3 @'h30014b {
    field DrvStrenEQHiDqP @0 {
       bits 6;
       access rw;
       reset 6'h0;
    }
    field DrvStrenEQLoDqN @6 {
       bits 6;
       access rw;
       reset 6'h0;
    }
  }
  register TxOdtDrvStren_b1_p3 @'h30014d {
    field ODTStrenP @0 {
       bits 6;
       access rw;
       reset 6'h0;
    }
    field ODTStrenN @6 {
       bits 6;
       access rw;
       reset 6'h0;
    }
  }
  register TxSlewRate_b1_p3 @'h30015f {
    field TxPreP @0 {
       bits 4;
       access rw;
       reset 4'hf;
    }
    field TxPreN @4 {
       bits 4;
       access rw;
       reset 4'hf;
    }
    field TxPreDrvMode @8 {
       bits 3;
       access rw;
       reset 3'h7;
    }
  }
  register RxEnDlyTg0_u1_p3 @'h300180 {
    field RxEnDlyTg0_u1_p3 @0 {
       bits 11;
       access rw;
       reset 11'h100;
    }
  }
  register RxEnDlyTg1_u1_p3 @'h300181 {
    field RxEnDlyTg1_u1_p3 @0 {
       bits 11;
       access rw;
       reset 11'h100;
    }
  }
  register RxEnDlyTg2_u1_p3 @'h300182 {
    field RxEnDlyTg2_u1_p3 @0 {
       bits 11;
       access rw;
       reset 11'h100;
    }
  }
  register RxEnDlyTg3_u1_p3 @'h300183 {
    field RxEnDlyTg3_u1_p3 @0 {
       bits 11;
       access rw;
       reset 11'h100;
    }
  }
  register RxClkDlyTg0_u1_p3 @'h30018c {
    field RxClkDlyTg0_u1_p3 @0 {
       bits 6;
       access rw;
       reset 6'h10;
    }
  }
  register RxClkDlyTg1_u1_p3 @'h30018d {
    field RxClkDlyTg1_u1_p3 @0 {
       bits 6;
       access rw;
       reset 6'h10;
    }
  }
  register RxClkDlyTg2_u1_p3 @'h30018e {
    field RxClkDlyTg2_u1_p3 @0 {
       bits 6;
       access rw;
       reset 6'h10;
    }
  }
  register RxClkDlyTg3_u1_p3 @'h30018f {
    field RxClkDlyTg3_u1_p3 @0 {
       bits 6;
       access rw;
       reset 6'h10;
    }
  }
  register RxClkcDlyTg0_u1_p3 @'h300190 {
    field RxClkcDlyTg0_u1_p3 @0 {
       bits 6;
       access rw;
       reset 6'h10;
    }
  }
  register RxClkcDlyTg1_u1_p3 @'h300191 {
    field RxClkcDlyTg1_u1_p3 @0 {
       bits 6;
       access rw;
       reset 6'h10;
    }
  }
  register RxClkcDlyTg2_u1_p3 @'h300192 {
    field RxClkcDlyTg2_u1_p3 @0 {
       bits 6;
       access rw;
       reset 6'h10;
    }
  }
  register RxClkcDlyTg3_u1_p3 @'h300193 {
    field RxClkcDlyTg3_u1_p3 @0 {
       bits 6;
       access rw;
       reset 6'h10;
    }
  }
  register TxDqDlyTg0_r1_p3 @'h3001c0 {
    field TxDqDlyTg0_r1_p3 @0 {
       bits 9;
       access rw;
       reset 9'h10;
    }
  }
  register TxDqDlyTg1_r1_p3 @'h3001c1 {
    field TxDqDlyTg1_r1_p3 @0 {
       bits 9;
       access rw;
       reset 9'h10;
    }
  }
  register TxDqDlyTg2_r1_p3 @'h3001c2 {
    field TxDqDlyTg2_r1_p3 @0 {
       bits 9;
       access rw;
       reset 9'h10;
    }
  }
  register TxDqDlyTg3_r1_p3 @'h3001c3 {
    field TxDqDlyTg3_r1_p3 @0 {
       bits 9;
       access rw;
       reset 9'h10;
    }
  }
  register TxDqsDlyTg0_u1_p3 @'h3001d0 {
    field TxDqsDlyTg0_u1_p3 @0 {
       bits 10;
       access rw;
       reset 10'h100;
    }
  }
  register TxDqsDlyTg1_u1_p3 @'h3001d1 {
    field TxDqsDlyTg1_u1_p3 @0 {
       bits 10;
       access rw;
       reset 10'h100;
    }
  }
  register TxDqsDlyTg2_u1_p3 @'h3001d2 {
    field TxDqsDlyTg2_u1_p3 @0 {
       bits 10;
       access rw;
       reset 10'h100;
    }
  }
  register TxDqsDlyTg3_u1_p3 @'h3001d3 {
    field TxDqsDlyTg3_u1_p3 @0 {
       bits 10;
       access rw;
       reset 10'h100;
    }
  }
  register TxDqDlyTg0_r2_p3 @'h3002c0 {
    field TxDqDlyTg0_r2_p3 @0 {
       bits 9;
       access rw;
       reset 9'h10;
    }
  }
  register TxDqDlyTg1_r2_p3 @'h3002c1 {
    field TxDqDlyTg1_r2_p3 @0 {
       bits 9;
       access rw;
       reset 9'h10;
    }
  }
  register TxDqDlyTg2_r2_p3 @'h3002c2 {
    field TxDqDlyTg2_r2_p3 @0 {
       bits 9;
       access rw;
       reset 9'h10;
    }
  }
  register TxDqDlyTg3_r2_p3 @'h3002c3 {
    field TxDqDlyTg3_r2_p3 @0 {
       bits 9;
       access rw;
       reset 9'h10;
    }
  }
  register TxDqDlyTg0_r3_p3 @'h3003c0 {
    field TxDqDlyTg0_r3_p3 @0 {
       bits 9;
       access rw;
       reset 9'h10;
    }
  }
  register TxDqDlyTg1_r3_p3 @'h3003c1 {
    field TxDqDlyTg1_r3_p3 @0 {
       bits 9;
       access rw;
       reset 9'h10;
    }
  }
  register TxDqDlyTg2_r3_p3 @'h3003c2 {
    field TxDqDlyTg2_r3_p3 @0 {
       bits 9;
       access rw;
       reset 9'h10;
    }
  }
  register TxDqDlyTg3_r3_p3 @'h3003c3 {
    field TxDqDlyTg3_r3_p3 @0 {
       bits 9;
       access rw;
       reset 9'h10;
    }
  }
  register TxDqDlyTg0_r4_p3 @'h3004c0 {
    field TxDqDlyTg0_r4_p3 @0 {
       bits 9;
       access rw;
       reset 9'h10;
    }
  }
  register TxDqDlyTg1_r4_p3 @'h3004c1 {
    field TxDqDlyTg1_r4_p3 @0 {
       bits 9;
       access rw;
       reset 9'h10;
    }
  }
  register TxDqDlyTg2_r4_p3 @'h3004c2 {
    field TxDqDlyTg2_r4_p3 @0 {
       bits 9;
       access rw;
       reset 9'h10;
    }
  }
  register TxDqDlyTg3_r4_p3 @'h3004c3 {
    field TxDqDlyTg3_r4_p3 @0 {
       bits 9;
       access rw;
       reset 9'h10;
    }
  }
  register TxDqDlyTg0_r5_p3 @'h3005c0 {
    field TxDqDlyTg0_r5_p3 @0 {
       bits 9;
       access rw;
       reset 9'h10;
    }
  }
  register TxDqDlyTg1_r5_p3 @'h3005c1 {
    field TxDqDlyTg1_r5_p3 @0 {
       bits 9;
       access rw;
       reset 9'h10;
    }
  }
  register TxDqDlyTg2_r5_p3 @'h3005c2 {
    field TxDqDlyTg2_r5_p3 @0 {
       bits 9;
       access rw;
       reset 9'h10;
    }
  }
  register TxDqDlyTg3_r5_p3 @'h3005c3 {
    field TxDqDlyTg3_r5_p3 @0 {
       bits 9;
       access rw;
       reset 9'h10;
    }
  }
  register TxDqDlyTg0_r6_p3 @'h3006c0 {
    field TxDqDlyTg0_r6_p3 @0 {
       bits 9;
       access rw;
       reset 9'h10;
    }
  }
  register TxDqDlyTg1_r6_p3 @'h3006c1 {
    field TxDqDlyTg1_r6_p3 @0 {
       bits 9;
       access rw;
       reset 9'h10;
    }
  }
  register TxDqDlyTg2_r6_p3 @'h3006c2 {
    field TxDqDlyTg2_r6_p3 @0 {
       bits 9;
       access rw;
       reset 9'h10;
    }
  }
  register TxDqDlyTg3_r6_p3 @'h3006c3 {
    field TxDqDlyTg3_r6_p3 @0 {
       bits 9;
       access rw;
       reset 9'h10;
    }
  }
  register TxDqDlyTg0_r7_p3 @'h3007c0 {
    field TxDqDlyTg0_r7_p3 @0 {
       bits 9;
       access rw;
       reset 9'h10;
    }
  }
  register TxDqDlyTg1_r7_p3 @'h3007c1 {
    field TxDqDlyTg1_r7_p3 @0 {
       bits 9;
       access rw;
       reset 9'h10;
    }
  }
  register TxDqDlyTg2_r7_p3 @'h3007c2 {
    field TxDqDlyTg2_r7_p3 @0 {
       bits 9;
       access rw;
       reset 9'h10;
    }
  }
  register TxDqDlyTg3_r7_p3 @'h3007c3 {
    field TxDqDlyTg3_r7_p3 @0 {
       bits 9;
       access rw;
       reset 9'h10;
    }
  }
  register TxDqDlyTg0_r8_p3 @'h3008c0 {
    field TxDqDlyTg0_r8_p3 @0 {
       bits 9;
       access rw;
       reset 9'h10;
    }
  }
  register TxDqDlyTg1_r8_p3 @'h3008c1 {
    field TxDqDlyTg1_r8_p3 @0 {
       bits 9;
       access rw;
       reset 9'h10;
    }
  }
  register TxDqDlyTg2_r8_p3 @'h3008c2 {
    field TxDqDlyTg2_r8_p3 @0 {
       bits 9;
       access rw;
       reset 9'h10;
    }
  }
  register TxDqDlyTg3_r8_p3 @'h3008c3 {
    field TxDqDlyTg3_r8_p3 @0 {
       bits 9;
       access rw;
       reset 9'h10;
    }
  }
}
block dwc_ddrphy_top_DWC_DDRPHYA_DBYTE9 {
  endian little;
  bytes 2;
  register DbyteMiscMode @'h0 {
    field Reserved @0 {
       bits 2;
    }
    field DByteDisable @2 {
       bits 1;
       access rw;
       reset 1'h0;
    }
  }
  register TsmByte0 @'h1 {
    field RFU_TsmByte0 @0 {
       bits 16;
       access rw;
       reset 16'h0;
    }
  }
  register TrainingParam @'h2 {
    field RFU_TrainingParam @0 {
       bits 16;
       access rw;
       reset 16'h0;
    }
  }
  register UseDqsEnReplica_p0 @'h3 {
    field UseDqsEnReplica_p0 @0 {
       bits 1;
       access rw;
       reset 1'h0;
    }
  }
  register RxTrainPatternEnable @'h10 {
    field RxTrainPatternEnable @0 {
       bits 1;
       access rw;
       reset 1'h0;
    }
  }
  register TsmByte1 @'h11 {
    field RFU_TsmByte1 @0 {
       bits 16;
       access rw;
       reset 16'h0;
    }
  }
  register TsmByte2 @'h12 {
    field RFU_TsmByte2 @0 {
       bits 16;
       access rw;
       reset 16'h0;
    }
  }
  register TsmByte3 @'h13 {
    field RFU_TsmByte3 @0 {
       bits 9;
       access rw;
       reset 9'h0;
    }
  }
  register TsmByte4 @'h14 {
    field RFU_TsmByte4 @0 {
       bits 4;
       access rw;
       reset 4'h0;
    }
  }
  register TestModeConfig @'h17 {
    field RFU_TestModeConfig @0 {
       bits 10;
       access rw;
       reset 10'h0;
    }
  }
  register TsmByte5 @'h18 {
    field RFU_TsmByte5 @0 {
       bits 16;
       access rw;
       reset 16'h0;
    }
  }
  register MtestMuxSel @'h1a {
    field MtestMuxSel @0 {
       bits 6;
       access rw;
       reset 6'h0;
    }
  }
  register DtsmTrainModeCtrl @'h1f {
    field RFU_DtsmTrainModeCtrl @0 {
       bits 4;
       access rw;
       reset 4'h0;
    }
  }
  register DFIMRL_p0 @'h20 {
    field DFIMRL_p0 @0 {
       bits 5;
       access rw;
       reset 5'h6;
    }
  }
  register AsyncDbyteMode @'h24 {
    field AsyncDbyteMode @0 {
       bits 9;
       access rw;
       reset 9'h0;
    }
  }
  register AsyncDbyteTxEn @'h26 {
    field AsyncDbyteTxEn @0 {
       bits 12;
       access rw;
       reset 12'h0;
    }
  }
  register AsyncDbyteTxData @'h28 {
    field AsyncDbyteTxData @0 {
       bits 12;
       access rw;
       reset 12'h0;
    }
  }
  register AsyncDbyteRxData @'h2a {
    field AsyncDbyteRxData @0 {
       bits 12;
       access ro;
       reset 12'h0;
    }
  }
  register VrefDAC1_r0 @'h30 {
    field VrefDAC1_r0 @0 {
       bits 7;
       access rw;
       reset 7'h0;
    }
  }
  register TrainingCntr_r0 @'h32 {
    field RFU_TrainingCntr_r0 @0 {
       bits 16;
       access rw;
       reset 16'h0;
    }
  }
  register VrefDAC0_r0 @'h40 {
    field VrefDAC0_r0 @0 {
       bits 7;
       access rw;
       reset 7'h0;
    }
  }
  register TxImpedanceCtrl0_b0_p0 @'h41 {
    field DrvStrenDqP @0 {
       bits 6;
       access rw;
       reset 6'h3f;
    }
    field DrvStrenDqN @6 {
       bits 6;
       access rw;
       reset 6'h3f;
    }
  }
  register DqDqsRcvCntrl_b0_p0 @'h43 {
    field SelAnalogVref @0 {
       bits 1;
       access rw;
       reset 1'h0;
    }
    field ExtVrefRange @1 {
       bits 1;
       access rw;
       reset 1'h0;
    }
    field DfeCtrl @2 {
       bits 2;
       access rw;
       reset 2'h0;
    }
    field MajorModeDbyte @4 {
       bits 3;
       access rw;
       reset 3'h3;
    }
    field GainCurrAdj @7 {
       bits 5;
       access rw;
       reset 5'hb;
    }
    field Reserved @12 {
       bits 4;
    }
  }
  register TxEqualizationMode_p0 @'h48 {
    field TxEqMode @0 {
       bits 2;
       access rw;
       reset 2'h0;
    }
  }
  register TxImpedanceCtrl1_b0_p0 @'h49 {
    field DrvStrenFSDqP @0 {
       bits 6;
       access rw;
       reset 6'h3f;
    }
    field DrvStrenFSDqN @6 {
       bits 6;
       access rw;
       reset 6'h3f;
    }
  }
  register DqDqsRcvCntrl1 @'h4a {
    field PowerDownRcvr @0 {
       bits 9;
       access rw;
       reset 9'h0;
    }
    field PowerDownRcvrDqs @9 {
       bits 1;
       access rw;
       reset 1'h0;
    }
    field RxPadStandbyEn @10 {
       bits 1;
       access rw;
       reset 1'h1;
    }
    field EnLPReqPDR @11 {
       bits 1;
       access rw;
       reset 1'h0;
    }
  }
  register TxImpedanceCtrl2_b0_p0 @'h4b {
    field DrvStrenEQHiDqP @0 {
       bits 6;
       access rw;
       reset 6'h0;
    }
    field DrvStrenEQLoDqN @6 {
       bits 6;
       access rw;
       reset 6'h0;
    }
  }
  register DqDqsRcvCntrl2_p0 @'h4c {
    field EnRxAgressivePDR @0 {
       bits 1;
       access rw;
       reset 1'h0;
    }
  }
  register TxOdtDrvStren_b0_p0 @'h4d {
    field ODTStrenP @0 {
       bits 6;
       access rw;
       reset 6'h0;
    }
    field ODTStrenN @6 {
       bits 6;
       access rw;
       reset 6'h0;
    }
  }
  register RxFifoCheckStatus @'h56 {
    field RxFifoLocErr @0 {
       bits 1;
       access ro;
       reset 1'h0;
    }
    field RxFifoLocUErr @1 {
       bits 1;
       access ro;
       reset 1'h0;
    }
  }
  register RxFifoCheckErrValues @'h57 {
    field RxFifoRdLocErrValue @0 {
       bits 4;
       access ro;
       reset 4'h0;
    }
    field RxFifoWrLocErrValue @4 {
       bits 4;
       access ro;
       reset 4'h0;
    }
    field RxFifoRdLocUErrValue @8 {
       bits 4;
       access ro;
       reset 4'h0;
    }
    field RxFifoWrLocUErrValue @12 {
       bits 4;
       access ro;
       reset 4'h0;
    }
  }
  register RxFifoInfo @'h58 {
    field RxFifoRdLoc @0 {
       bits 4;
       access ro;
       reset 4'h0;
    }
    field RxFifoWrLoc @4 {
       bits 4;
       access ro;
       reset 4'h0;
    }
    field RxFifoRdLocU @8 {
       bits 4;
       access ro;
       reset 4'h0;
    }
    field RxFifoWrLocU @12 {
       bits 4;
       access ro;
       reset 4'h0;
    }
  }
  register RxFifoVisibility @'h59 {
    field RxFifoRdPtr @0 {
       bits 3;
       access rw;
       reset 3'h0;
    }
    field RxFifoRdPtrOvr @3 {
       bits 1;
       access rw;
       reset 1'h0;
    }
    field RxFifoRdEn @4 {
       bits 1;
       access rw;
       reset 1'h0;
    }
  }
  register RxFifoContentsDQ3210 @'h5a {
    field RxFifoContentsDQ3210 @0 {
       bits 16;
       access ro;
       reset 16'h0;
    }
  }
  register RxFifoContentsDQ7654 @'h5b {
    field RxFifoContentsDQ7654 @0 {
       bits 16;
       access ro;
       reset 16'h0;
    }
  }
  register RxFifoContentsDBI @'h5c {
    field RxFifoContentsDBI @0 {
       bits 4;
       access ro;
       reset 4'h0;
    }
  }
  register TxSlewRate_b0_p0 @'h5f {
    field TxPreP @0 {
       bits 4;
       access rw;
       reset 4'hf;
    }
    field TxPreN @4 {
       bits 4;
       access rw;
       reset 4'hf;
    }
    field TxPreDrvMode @8 {
       bits 3;
       access rw;
       reset 3'h7;
    }
  }
  register TrainingIncDecDtsmEn_r0 @'h62 {
    field TrainingIncDecDtsmEn_r0 @0 {
       bits 9;
       access rw;
       reset 9'h0;
    }
  }
  register RxPBDlyTg0_r0 @'h68 {
    field RxPBDlyTg0_r0 @0 {
       bits 7;
       access rw;
       reset 7'h0;
    }
  }
  register RxPBDlyTg1_r0 @'h69 {
    field RxPBDlyTg1_r0 @0 {
       bits 7;
       access rw;
       reset 7'h0;
    }
  }
  register RxPBDlyTg2_r0 @'h6a {
    field RxPBDlyTg2_r0 @0 {
       bits 7;
       access rw;
       reset 7'h0;
    }
  }
  register RxPBDlyTg3_r0 @'h6b {
    field RxPBDlyTg3_r0 @0 {
       bits 7;
       access rw;
       reset 7'h0;
    }
  }
  register RxEnDlyTg0_u0_p0 @'h80 {
    field RxEnDlyTg0_u0_p0 @0 {
       bits 11;
       access rw;
       reset 11'h100;
    }
  }
  register RxEnDlyTg1_u0_p0 @'h81 {
    field RxEnDlyTg1_u0_p0 @0 {
       bits 11;
       access rw;
       reset 11'h100;
    }
  }
  register RxEnDlyTg2_u0_p0 @'h82 {
    field RxEnDlyTg2_u0_p0 @0 {
       bits 11;
       access rw;
       reset 11'h100;
    }
  }
  register RxEnDlyTg3_u0_p0 @'h83 {
    field RxEnDlyTg3_u0_p0 @0 {
       bits 11;
       access rw;
       reset 11'h100;
    }
  }
  register RxClkDlyTg0_u0_p0 @'h8c {
    field RxClkDlyTg0_u0_p0 @0 {
       bits 6;
       access rw;
       reset 6'h10;
    }
  }
  register RxClkDlyTg1_u0_p0 @'h8d {
    field RxClkDlyTg1_u0_p0 @0 {
       bits 6;
       access rw;
       reset 6'h10;
    }
  }
  register RxClkDlyTg2_u0_p0 @'h8e {
    field RxClkDlyTg2_u0_p0 @0 {
       bits 6;
       access rw;
       reset 6'h10;
    }
  }
  register RxClkDlyTg3_u0_p0 @'h8f {
    field RxClkDlyTg3_u0_p0 @0 {
       bits 6;
       access rw;
       reset 6'h10;
    }
  }
  register RxClkcDlyTg0_u0_p0 @'h90 {
    field RxClkcDlyTg0_u0_p0 @0 {
       bits 6;
       access rw;
       reset 6'h10;
    }
  }
  register RxClkcDlyTg1_u0_p0 @'h91 {
    field RxClkcDlyTg1_u0_p0 @0 {
       bits 6;
       access rw;
       reset 6'h10;
    }
  }
  register RxClkcDlyTg2_u0_p0 @'h92 {
    field RxClkcDlyTg2_u0_p0 @0 {
       bits 6;
       access rw;
       reset 6'h10;
    }
  }
  register RxClkcDlyTg3_u0_p0 @'h93 {
    field RxClkcDlyTg3_u0_p0 @0 {
       bits 6;
       access rw;
       reset 6'h10;
    }
  }
  register Dq0LnSel @'ha0 {
    field Dq0LnSel @0 {
       bits 3;
       access rw;
       reset 3'h0;
    }
  }
  register Dq1LnSel @'ha1 {
    field Dq1LnSel @0 {
       bits 3;
       access rw;
       reset 3'h1;
    }
  }
  register Dq2LnSel @'ha2 {
    field Dq2LnSel @0 {
       bits 3;
       access rw;
       reset 3'h2;
    }
  }
  register Dq3LnSel @'ha3 {
    field Dq3LnSel @0 {
       bits 3;
       access rw;
       reset 3'h3;
    }
  }
  register Dq4LnSel @'ha4 {
    field Dq4LnSel @0 {
       bits 3;
       access rw;
       reset 3'h4;
    }
  }
  register Dq5LnSel @'ha5 {
    field Dq5LnSel @0 {
       bits 3;
       access rw;
       reset 3'h5;
    }
  }
  register Dq6LnSel @'ha6 {
    field Dq6LnSel @0 {
       bits 3;
       access rw;
       reset 3'h6;
    }
  }
  register Dq7LnSel @'ha7 {
    field Dq7LnSel @0 {
       bits 3;
       access rw;
       reset 3'h7;
    }
  }
  register PptCtlStatic @'haa {
    field RFU_PptCtlStatic @0 {
       bits 12;
       access rw;
       reset 12'h0;
    }
  }
  register PptCtlDyn @'hab {
    field RFU_PptCtlDyn @0 {
       bits 2;
       access rw;
       reset 2'h0;
    }
  }
  register PptInfo @'hac {
    field PptInfo @0 {
       bits 16;
       access ro;
       reset 16'h0;
    }
  }
  register PptRxEnEvnt @'had {
    field RFU_PptRxEnEvnt @0 {
       bits 2;
       access rw;
       reset 2'h0;
    }
  }
  register PptDqsCntInvTrnTg0_p0 @'hae {
    field PptDqsCntInvTrnTg0_p0 @0 {
       bits 16;
       access rw;
       reset 16'h0;
    }
  }
  register PptDqsCntInvTrnTg1_p0 @'haf {
    field PptDqsCntInvTrnTg1_p0 @0 {
       bits 16;
       access rw;
       reset 16'h0;
    }
  }
  register DtsmBlankingCtrl @'hb1 {
    field RFU_DtsmBlankingCtrl @0 {
       bits 10;
       access rw;
       reset 10'h0;
    }
  }
  register Tsm0_i0 @'hb2 {
    field RFU_Tsm0_i0 @0 {
       bits 14;
       access rw;
       reset 14'h0;
    }
  }
  register Tsm1_i0 @'hb3 {
    field RFU_Tsm1_i0 @0 {
       bits 16;
       access ro;
       reset 16'h0;
    }
  }
  register Tsm2_i0 @'hb4 {
    field RFU_Tsm2_i0 @0 {
       bits 1;
       access rw;
       reset 1'h0;
    }
  }
  register Tsm3 @'hb5 {
    field RFU_Tsm3 @0 {
       bits 10;
       access rw;
       reset 10'h0;
    }
  }
  register TxChkDataSelects @'hb6 {
    field RFU_TxChkDataSelects @0 {
       bits 2;
       access rw;
       reset 2'h0;
    }
  }
  register DtsmUpThldXingInd @'hb7 {
    field DtsmUpThldXingInd @0 {
       bits 9;
       access ro;
       reset 9'h0;
    }
  }
  register DtsmLoThldXingInd @'hb8 {
    field DtsmLoThldXingInd @0 {
       bits 9;
       access ro;
       reset 9'h0;
    }
  }
  register DbyteAllDtsmCtrl0 @'hb9 {
    field RFU_DbyteAllDtsmCtrl0 @0 {
       bits 9;
       access rw;
       reset 9'h0;
    }
  }
  register DbyteAllDtsmCtrl1 @'hba {
    field RFU_DbyteAllDtsmCtrl1 @0 {
       bits 9;
       access rw;
       reset 9'h0;
    }
  }
  register DbyteAllDtsmCtrl2 @'hbb {
    field RFU_DbyteAllDtsmCtrl2 @0 {
       bits 9;
       access rw;
       reset 9'h0;
    }
  }
  register TxDqDlyTg0_r0_p0 @'hc0 {
    field TxDqDlyTg0_r0_p0 @0 {
       bits 9;
       access rw;
       reset 9'h10;
    }
  }
  register TxDqDlyTg1_r0_p0 @'hc1 {
    field TxDqDlyTg1_r0_p0 @0 {
       bits 9;
       access rw;
       reset 9'h10;
    }
  }
  register TxDqDlyTg2_r0_p0 @'hc2 {
    field TxDqDlyTg2_r0_p0 @0 {
       bits 9;
       access rw;
       reset 9'h10;
    }
  }
  register TxDqDlyTg3_r0_p0 @'hc3 {
    field TxDqDlyTg3_r0_p0 @0 {
       bits 9;
       access rw;
       reset 9'h10;
    }
  }
  register TxDqsDlyTg0_u0_p0 @'hd0 {
    field TxDqsDlyTg0_u0_p0 @0 {
       bits 10;
       access rw;
       reset 10'h100;
    }
  }
  register TxDqsDlyTg1_u0_p0 @'hd1 {
    field TxDqsDlyTg1_u0_p0 @0 {
       bits 10;
       access rw;
       reset 10'h100;
    }
  }
  register TxDqsDlyTg2_u0_p0 @'hd2 {
    field TxDqsDlyTg2_u0_p0 @0 {
       bits 10;
       access rw;
       reset 10'h100;
    }
  }
  register TxDqsDlyTg3_u0_p0 @'hd3 {
    field TxDqsDlyTg3_u0_p0 @0 {
       bits 10;
       access rw;
       reset 10'h100;
    }
  }
  register DxLcdlStatus @'he4 {
    field DxLcdlFineSnapVal @0 {
       bits 10;
       access ro;
       reset 10'h0;
    }
    field DxLcdlPhdSnapVal @10 {
       bits 1;
       access ro;
       reset 1'h0;
    }
    field DxLcdlStickyLock @11 {
       bits 1;
       access ro;
       reset 1'h0;
    }
    field DxLcdlStickyUnlock @12 {
       bits 1;
       access ro;
       reset 1'h0;
    }
    field DxLcdlLiveLock @13 {
       bits 1;
       access ro;
       reset 1'h0;
    }
  }
  register VrefDAC1_r1 @'h130 {
    field VrefDAC1_r1 @0 {
       bits 7;
       access rw;
       reset 7'h0;
    }
  }
  register TrainingCntr_r1 @'h132 {
    field RFU_TrainingCntr_r1 @0 {
       bits 16;
       access rw;
       reset 16'h0;
    }
  }
  register VrefDAC0_r1 @'h140 {
    field VrefDAC0_r1 @0 {
       bits 7;
       access rw;
       reset 7'h0;
    }
  }
  register TxImpedanceCtrl0_b1_p0 @'h141 {
    field DrvStrenDqP @0 {
       bits 6;
       access rw;
       reset 6'h3f;
    }
    field DrvStrenDqN @6 {
       bits 6;
       access rw;
       reset 6'h3f;
    }
  }
  register DqDqsRcvCntrl_b1_p0 @'h143 {
    field SelAnalogVref @0 {
       bits 1;
       access rw;
       reset 1'h0;
    }
    field ExtVrefRange @1 {
       bits 1;
       access rw;
       reset 1'h0;
    }
    field DfeCtrl @2 {
       bits 2;
       access rw;
       reset 2'h0;
    }
    field MajorModeDbyte @4 {
       bits 3;
       access rw;
       reset 3'h3;
    }
    field GainCurrAdj @7 {
       bits 5;
       access rw;
       reset 5'hb;
    }
    field Reserved @12 {
       bits 4;
    }
  }
  register TxImpedanceCtrl1_b1_p0 @'h149 {
    field DrvStrenFSDqP @0 {
       bits 6;
       access rw;
       reset 6'h3f;
    }
    field DrvStrenFSDqN @6 {
       bits 6;
       access rw;
       reset 6'h3f;
    }
  }
  register TxImpedanceCtrl2_b1_p0 @'h14b {
    field DrvStrenEQHiDqP @0 {
       bits 6;
       access rw;
       reset 6'h0;
    }
    field DrvStrenEQLoDqN @6 {
       bits 6;
       access rw;
       reset 6'h0;
    }
  }
  register TxOdtDrvStren_b1_p0 @'h14d {
    field ODTStrenP @0 {
       bits 6;
       access rw;
       reset 6'h0;
    }
    field ODTStrenN @6 {
       bits 6;
       access rw;
       reset 6'h0;
    }
  }
  register TxSlewRate_b1_p0 @'h15f {
    field TxPreP @0 {
       bits 4;
       access rw;
       reset 4'hf;
    }
    field TxPreN @4 {
       bits 4;
       access rw;
       reset 4'hf;
    }
    field TxPreDrvMode @8 {
       bits 3;
       access rw;
       reset 3'h7;
    }
  }
  register TrainingIncDecDtsmEn_r1 @'h162 {
    field TrainingIncDecDtsmEn_r1 @0 {
       bits 9;
       access rw;
       reset 9'h0;
    }
  }
  register RxPBDlyTg0_r1 @'h168 {
    field RxPBDlyTg0_r1 @0 {
       bits 7;
       access rw;
       reset 7'h0;
    }
  }
  register RxPBDlyTg1_r1 @'h169 {
    field RxPBDlyTg1_r1 @0 {
       bits 7;
       access rw;
       reset 7'h0;
    }
  }
  register RxPBDlyTg2_r1 @'h16a {
    field RxPBDlyTg2_r1 @0 {
       bits 7;
       access rw;
       reset 7'h0;
    }
  }
  register RxPBDlyTg3_r1 @'h16b {
    field RxPBDlyTg3_r1 @0 {
       bits 7;
       access rw;
       reset 7'h0;
    }
  }
  register RxEnDlyTg0_u1_p0 @'h180 {
    field RxEnDlyTg0_u1_p0 @0 {
       bits 11;
       access rw;
       reset 11'h100;
    }
  }
  register RxEnDlyTg1_u1_p0 @'h181 {
    field RxEnDlyTg1_u1_p0 @0 {
       bits 11;
       access rw;
       reset 11'h100;
    }
  }
  register RxEnDlyTg2_u1_p0 @'h182 {
    field RxEnDlyTg2_u1_p0 @0 {
       bits 11;
       access rw;
       reset 11'h100;
    }
  }
  register RxEnDlyTg3_u1_p0 @'h183 {
    field RxEnDlyTg3_u1_p0 @0 {
       bits 11;
       access rw;
       reset 11'h100;
    }
  }
  register RxClkDlyTg0_u1_p0 @'h18c {
    field RxClkDlyTg0_u1_p0 @0 {
       bits 6;
       access rw;
       reset 6'h10;
    }
  }
  register RxClkDlyTg1_u1_p0 @'h18d {
    field RxClkDlyTg1_u1_p0 @0 {
       bits 6;
       access rw;
       reset 6'h10;
    }
  }
  register RxClkDlyTg2_u1_p0 @'h18e {
    field RxClkDlyTg2_u1_p0 @0 {
       bits 6;
       access rw;
       reset 6'h10;
    }
  }
  register RxClkDlyTg3_u1_p0 @'h18f {
    field RxClkDlyTg3_u1_p0 @0 {
       bits 6;
       access rw;
       reset 6'h10;
    }
  }
  register RxClkcDlyTg0_u1_p0 @'h190 {
    field RxClkcDlyTg0_u1_p0 @0 {
       bits 6;
       access rw;
       reset 6'h10;
    }
  }
  register RxClkcDlyTg1_u1_p0 @'h191 {
    field RxClkcDlyTg1_u1_p0 @0 {
       bits 6;
       access rw;
       reset 6'h10;
    }
  }
  register RxClkcDlyTg2_u1_p0 @'h192 {
    field RxClkcDlyTg2_u1_p0 @0 {
       bits 6;
       access rw;
       reset 6'h10;
    }
  }
  register RxClkcDlyTg3_u1_p0 @'h193 {
    field RxClkcDlyTg3_u1_p0 @0 {
       bits 6;
       access rw;
       reset 6'h10;
    }
  }
  register Tsm0_i1 @'h1b2 {
    field RFU_Tsm0_i1 @0 {
       bits 14;
       access rw;
       reset 14'h0;
    }
  }
  register Tsm1_i1 @'h1b3 {
    field RFU_Tsm1_i1 @0 {
       bits 16;
       access ro;
       reset 16'h0;
    }
  }
  register Tsm2_i1 @'h1b4 {
    field RFU_Tsm2_i1 @0 {
       bits 1;
       access rw;
       reset 1'h0;
    }
  }
  register TxDqDlyTg0_r1_p0 @'h1c0 {
    field TxDqDlyTg0_r1_p0 @0 {
       bits 9;
       access rw;
       reset 9'h10;
    }
  }
  register TxDqDlyTg1_r1_p0 @'h1c1 {
    field TxDqDlyTg1_r1_p0 @0 {
       bits 9;
       access rw;
       reset 9'h10;
    }
  }
  register TxDqDlyTg2_r1_p0 @'h1c2 {
    field TxDqDlyTg2_r1_p0 @0 {
       bits 9;
       access rw;
       reset 9'h10;
    }
  }
  register TxDqDlyTg3_r1_p0 @'h1c3 {
    field TxDqDlyTg3_r1_p0 @0 {
       bits 9;
       access rw;
       reset 9'h10;
    }
  }
  register TxDqsDlyTg0_u1_p0 @'h1d0 {
    field TxDqsDlyTg0_u1_p0 @0 {
       bits 10;
       access rw;
       reset 10'h100;
    }
  }
  register TxDqsDlyTg1_u1_p0 @'h1d1 {
    field TxDqsDlyTg1_u1_p0 @0 {
       bits 10;
       access rw;
       reset 10'h100;
    }
  }
  register TxDqsDlyTg2_u1_p0 @'h1d2 {
    field TxDqsDlyTg2_u1_p0 @0 {
       bits 10;
       access rw;
       reset 10'h100;
    }
  }
  register TxDqsDlyTg3_u1_p0 @'h1d3 {
    field TxDqsDlyTg3_u1_p0 @0 {
       bits 10;
       access rw;
       reset 10'h100;
    }
  }
  register VrefDAC1_r2 @'h230 {
    field VrefDAC1_r2 @0 {
       bits 7;
       access rw;
       reset 7'h0;
    }
  }
  register TrainingCntr_r2 @'h232 {
    field RFU_TrainingCntr_r2 @0 {
       bits 16;
       access rw;
       reset 16'h0;
    }
  }
  register VrefDAC0_r2 @'h240 {
    field VrefDAC0_r2 @0 {
       bits 7;
       access rw;
       reset 7'h0;
    }
  }
  register TrainingIncDecDtsmEn_r2 @'h262 {
    field TrainingIncDecDtsmEn_r2 @0 {
       bits 9;
       access rw;
       reset 9'h0;
    }
  }
  register RxPBDlyTg0_r2 @'h268 {
    field RxPBDlyTg0_r2 @0 {
       bits 7;
       access rw;
       reset 7'h0;
    }
  }
  register RxPBDlyTg1_r2 @'h269 {
    field RxPBDlyTg1_r2 @0 {
       bits 7;
       access rw;
       reset 7'h0;
    }
  }
  register RxPBDlyTg2_r2 @'h26a {
    field RxPBDlyTg2_r2 @0 {
       bits 7;
       access rw;
       reset 7'h0;
    }
  }
  register RxPBDlyTg3_r2 @'h26b {
    field RxPBDlyTg3_r2 @0 {
       bits 7;
       access rw;
       reset 7'h0;
    }
  }
  register Tsm0_i2 @'h2b2 {
    field RFU_Tsm0_i2 @0 {
       bits 14;
       access rw;
       reset 14'h0;
    }
  }
  register Tsm1_i2 @'h2b3 {
    field RFU_Tsm1_i2 @0 {
       bits 16;
       access ro;
       reset 16'h0;
    }
  }
  register Tsm2_i2 @'h2b4 {
    field RFU_Tsm2_i2 @0 {
       bits 1;
       access rw;
       reset 1'h0;
    }
  }
  register TxDqDlyTg0_r2_p0 @'h2c0 {
    field TxDqDlyTg0_r2_p0 @0 {
       bits 9;
       access rw;
       reset 9'h10;
    }
  }
  register TxDqDlyTg1_r2_p0 @'h2c1 {
    field TxDqDlyTg1_r2_p0 @0 {
       bits 9;
       access rw;
       reset 9'h10;
    }
  }
  register TxDqDlyTg2_r2_p0 @'h2c2 {
    field TxDqDlyTg2_r2_p0 @0 {
       bits 9;
       access rw;
       reset 9'h10;
    }
  }
  register TxDqDlyTg3_r2_p0 @'h2c3 {
    field TxDqDlyTg3_r2_p0 @0 {
       bits 9;
       access rw;
       reset 9'h10;
    }
  }
  register VrefDAC1_r3 @'h330 {
    field VrefDAC1_r3 @0 {
       bits 7;
       access rw;
       reset 7'h0;
    }
  }
  register TrainingCntr_r3 @'h332 {
    field RFU_TrainingCntr_r3 @0 {
       bits 16;
       access rw;
       reset 16'h0;
    }
  }
  register VrefDAC0_r3 @'h340 {
    field VrefDAC0_r3 @0 {
       bits 7;
       access rw;
       reset 7'h0;
    }
  }
  register TrainingIncDecDtsmEn_r3 @'h362 {
    field TrainingIncDecDtsmEn_r3 @0 {
       bits 9;
       access rw;
       reset 9'h0;
    }
  }
  register RxPBDlyTg0_r3 @'h368 {
    field RxPBDlyTg0_r3 @0 {
       bits 7;
       access rw;
       reset 7'h0;
    }
  }
  register RxPBDlyTg1_r3 @'h369 {
    field RxPBDlyTg1_r3 @0 {
       bits 7;
       access rw;
       reset 7'h0;
    }
  }
  register RxPBDlyTg2_r3 @'h36a {
    field RxPBDlyTg2_r3 @0 {
       bits 7;
       access rw;
       reset 7'h0;
    }
  }
  register RxPBDlyTg3_r3 @'h36b {
    field RxPBDlyTg3_r3 @0 {
       bits 7;
       access rw;
       reset 7'h0;
    }
  }
  register Tsm0_i3 @'h3b2 {
    field RFU_Tsm0_i3 @0 {
       bits 14;
       access rw;
       reset 14'h0;
    }
  }
  register Tsm1_i3 @'h3b3 {
    field RFU_Tsm1_i3 @0 {
       bits 16;
       access ro;
       reset 16'h0;
    }
  }
  register Tsm2_i3 @'h3b4 {
    field RFU_Tsm2_i3 @0 {
       bits 1;
       access rw;
       reset 1'h0;
    }
  }
  register TxDqDlyTg0_r3_p0 @'h3c0 {
    field TxDqDlyTg0_r3_p0 @0 {
       bits 9;
       access rw;
       reset 9'h10;
    }
  }
  register TxDqDlyTg1_r3_p0 @'h3c1 {
    field TxDqDlyTg1_r3_p0 @0 {
       bits 9;
       access rw;
       reset 9'h10;
    }
  }
  register TxDqDlyTg2_r3_p0 @'h3c2 {
    field TxDqDlyTg2_r3_p0 @0 {
       bits 9;
       access rw;
       reset 9'h10;
    }
  }
  register TxDqDlyTg3_r3_p0 @'h3c3 {
    field TxDqDlyTg3_r3_p0 @0 {
       bits 9;
       access rw;
       reset 9'h10;
    }
  }
  register VrefDAC1_r4 @'h430 {
    field VrefDAC1_r4 @0 {
       bits 7;
       access rw;
       reset 7'h0;
    }
  }
  register TrainingCntr_r4 @'h432 {
    field RFU_TrainingCntr_r4 @0 {
       bits 16;
       access rw;
       reset 16'h0;
    }
  }
  register VrefDAC0_r4 @'h440 {
    field VrefDAC0_r4 @0 {
       bits 7;
       access rw;
       reset 7'h0;
    }
  }
  register TrainingIncDecDtsmEn_r4 @'h462 {
    field TrainingIncDecDtsmEn_r4 @0 {
       bits 9;
       access rw;
       reset 9'h0;
    }
  }
  register RxPBDlyTg0_r4 @'h468 {
    field RxPBDlyTg0_r4 @0 {
       bits 7;
       access rw;
       reset 7'h0;
    }
  }
  register RxPBDlyTg1_r4 @'h469 {
    field RxPBDlyTg1_r4 @0 {
       bits 7;
       access rw;
       reset 7'h0;
    }
  }
  register RxPBDlyTg2_r4 @'h46a {
    field RxPBDlyTg2_r4 @0 {
       bits 7;
       access rw;
       reset 7'h0;
    }
  }
  register RxPBDlyTg3_r4 @'h46b {
    field RxPBDlyTg3_r4 @0 {
       bits 7;
       access rw;
       reset 7'h0;
    }
  }
  register Tsm0_i4 @'h4b2 {
    field RFU_Tsm0_i4 @0 {
       bits 14;
       access rw;
       reset 14'h0;
    }
  }
  register Tsm1_i4 @'h4b3 {
    field RFU_Tsm1_i4 @0 {
       bits 16;
       access ro;
       reset 16'h0;
    }
  }
  register Tsm2_i4 @'h4b4 {
    field RFU_Tsm2_i4 @0 {
       bits 1;
       access rw;
       reset 1'h0;
    }
  }
  register TxDqDlyTg0_r4_p0 @'h4c0 {
    field TxDqDlyTg0_r4_p0 @0 {
       bits 9;
       access rw;
       reset 9'h10;
    }
  }
  register TxDqDlyTg1_r4_p0 @'h4c1 {
    field TxDqDlyTg1_r4_p0 @0 {
       bits 9;
       access rw;
       reset 9'h10;
    }
  }
  register TxDqDlyTg2_r4_p0 @'h4c2 {
    field TxDqDlyTg2_r4_p0 @0 {
       bits 9;
       access rw;
       reset 9'h10;
    }
  }
  register TxDqDlyTg3_r4_p0 @'h4c3 {
    field TxDqDlyTg3_r4_p0 @0 {
       bits 9;
       access rw;
       reset 9'h10;
    }
  }
  register VrefDAC1_r5 @'h530 {
    field VrefDAC1_r5 @0 {
       bits 7;
       access rw;
       reset 7'h0;
    }
  }
  register TrainingCntr_r5 @'h532 {
    field RFU_TrainingCntr_r5 @0 {
       bits 16;
       access rw;
       reset 16'h0;
    }
  }
  register VrefDAC0_r5 @'h540 {
    field VrefDAC0_r5 @0 {
       bits 7;
       access rw;
       reset 7'h0;
    }
  }
  register TrainingIncDecDtsmEn_r5 @'h562 {
    field TrainingIncDecDtsmEn_r5 @0 {
       bits 9;
       access rw;
       reset 9'h0;
    }
  }
  register RxPBDlyTg0_r5 @'h568 {
    field RxPBDlyTg0_r5 @0 {
       bits 7;
       access rw;
       reset 7'h0;
    }
  }
  register RxPBDlyTg1_r5 @'h569 {
    field RxPBDlyTg1_r5 @0 {
       bits 7;
       access rw;
       reset 7'h0;
    }
  }
  register RxPBDlyTg2_r5 @'h56a {
    field RxPBDlyTg2_r5 @0 {
       bits 7;
       access rw;
       reset 7'h0;
    }
  }
  register RxPBDlyTg3_r5 @'h56b {
    field RxPBDlyTg3_r5 @0 {
       bits 7;
       access rw;
       reset 7'h0;
    }
  }
  register Tsm0_i5 @'h5b2 {
    field RFU_Tsm0_i5 @0 {
       bits 14;
       access rw;
       reset 14'h0;
    }
  }
  register Tsm1_i5 @'h5b3 {
    field RFU_Tsm1_i5 @0 {
       bits 16;
       access ro;
       reset 16'h0;
    }
  }
  register Tsm2_i5 @'h5b4 {
    field RFU_Tsm2_i5 @0 {
       bits 1;
       access rw;
       reset 1'h0;
    }
  }
  register TxDqDlyTg0_r5_p0 @'h5c0 {
    field TxDqDlyTg0_r5_p0 @0 {
       bits 9;
       access rw;
       reset 9'h10;
    }
  }
  register TxDqDlyTg1_r5_p0 @'h5c1 {
    field TxDqDlyTg1_r5_p0 @0 {
       bits 9;
       access rw;
       reset 9'h10;
    }
  }
  register TxDqDlyTg2_r5_p0 @'h5c2 {
    field TxDqDlyTg2_r5_p0 @0 {
       bits 9;
       access rw;
       reset 9'h10;
    }
  }
  register TxDqDlyTg3_r5_p0 @'h5c3 {
    field TxDqDlyTg3_r5_p0 @0 {
       bits 9;
       access rw;
       reset 9'h10;
    }
  }
  register VrefDAC1_r6 @'h630 {
    field VrefDAC1_r6 @0 {
       bits 7;
       access rw;
       reset 7'h0;
    }
  }
  register TrainingCntr_r6 @'h632 {
    field RFU_TrainingCntr_r6 @0 {
       bits 16;
       access rw;
       reset 16'h0;
    }
  }
  register VrefDAC0_r6 @'h640 {
    field VrefDAC0_r6 @0 {
       bits 7;
       access rw;
       reset 7'h0;
    }
  }
  register TrainingIncDecDtsmEn_r6 @'h662 {
    field TrainingIncDecDtsmEn_r6 @0 {
       bits 9;
       access rw;
       reset 9'h0;
    }
  }
  register RxPBDlyTg0_r6 @'h668 {
    field RxPBDlyTg0_r6 @0 {
       bits 7;
       access rw;
       reset 7'h0;
    }
  }
  register RxPBDlyTg1_r6 @'h669 {
    field RxPBDlyTg1_r6 @0 {
       bits 7;
       access rw;
       reset 7'h0;
    }
  }
  register RxPBDlyTg2_r6 @'h66a {
    field RxPBDlyTg2_r6 @0 {
       bits 7;
       access rw;
       reset 7'h0;
    }
  }
  register RxPBDlyTg3_r6 @'h66b {
    field RxPBDlyTg3_r6 @0 {
       bits 7;
       access rw;
       reset 7'h0;
    }
  }
  register Tsm0_i6 @'h6b2 {
    field RFU_Tsm0_i6 @0 {
       bits 14;
       access rw;
       reset 14'h0;
    }
  }
  register Tsm1_i6 @'h6b3 {
    field RFU_Tsm1_i6 @0 {
       bits 16;
       access ro;
       reset 16'h0;
    }
  }
  register Tsm2_i6 @'h6b4 {
    field RFU_Tsm2_i6 @0 {
       bits 1;
       access rw;
       reset 1'h0;
    }
  }
  register TxDqDlyTg0_r6_p0 @'h6c0 {
    field TxDqDlyTg0_r6_p0 @0 {
       bits 9;
       access rw;
       reset 9'h10;
    }
  }
  register TxDqDlyTg1_r6_p0 @'h6c1 {
    field TxDqDlyTg1_r6_p0 @0 {
       bits 9;
       access rw;
       reset 9'h10;
    }
  }
  register TxDqDlyTg2_r6_p0 @'h6c2 {
    field TxDqDlyTg2_r6_p0 @0 {
       bits 9;
       access rw;
       reset 9'h10;
    }
  }
  register TxDqDlyTg3_r6_p0 @'h6c3 {
    field TxDqDlyTg3_r6_p0 @0 {
       bits 9;
       access rw;
       reset 9'h10;
    }
  }
  register VrefDAC1_r7 @'h730 {
    field VrefDAC1_r7 @0 {
       bits 7;
       access rw;
       reset 7'h0;
    }
  }
  register TrainingCntr_r7 @'h732 {
    field RFU_TrainingCntr_r7 @0 {
       bits 16;
       access rw;
       reset 16'h0;
    }
  }
  register VrefDAC0_r7 @'h740 {
    field VrefDAC0_r7 @0 {
       bits 7;
       access rw;
       reset 7'h0;
    }
  }
  register TrainingIncDecDtsmEn_r7 @'h762 {
    field TrainingIncDecDtsmEn_r7 @0 {
       bits 9;
       access rw;
       reset 9'h0;
    }
  }
  register RxPBDlyTg0_r7 @'h768 {
    field RxPBDlyTg0_r7 @0 {
       bits 7;
       access rw;
       reset 7'h0;
    }
  }
  register RxPBDlyTg1_r7 @'h769 {
    field RxPBDlyTg1_r7 @0 {
       bits 7;
       access rw;
       reset 7'h0;
    }
  }
  register RxPBDlyTg2_r7 @'h76a {
    field RxPBDlyTg2_r7 @0 {
       bits 7;
       access rw;
       reset 7'h0;
    }
  }
  register RxPBDlyTg3_r7 @'h76b {
    field RxPBDlyTg3_r7 @0 {
       bits 7;
       access rw;
       reset 7'h0;
    }
  }
  register Tsm0_i7 @'h7b2 {
    field RFU_Tsm0_i7 @0 {
       bits 14;
       access rw;
       reset 14'h0;
    }
  }
  register Tsm1_i7 @'h7b3 {
    field RFU_Tsm1_i7 @0 {
       bits 16;
       access ro;
       reset 16'h0;
    }
  }
  register Tsm2_i7 @'h7b4 {
    field RFU_Tsm2_i7 @0 {
       bits 1;
       access rw;
       reset 1'h0;
    }
  }
  register TxDqDlyTg0_r7_p0 @'h7c0 {
    field TxDqDlyTg0_r7_p0 @0 {
       bits 9;
       access rw;
       reset 9'h10;
    }
  }
  register TxDqDlyTg1_r7_p0 @'h7c1 {
    field TxDqDlyTg1_r7_p0 @0 {
       bits 9;
       access rw;
       reset 9'h10;
    }
  }
  register TxDqDlyTg2_r7_p0 @'h7c2 {
    field TxDqDlyTg2_r7_p0 @0 {
       bits 9;
       access rw;
       reset 9'h10;
    }
  }
  register TxDqDlyTg3_r7_p0 @'h7c3 {
    field TxDqDlyTg3_r7_p0 @0 {
       bits 9;
       access rw;
       reset 9'h10;
    }
  }
  register VrefDAC1_r8 @'h830 {
    field VrefDAC1_r8 @0 {
       bits 7;
       access rw;
       reset 7'h0;
    }
  }
  register TrainingCntr_r8 @'h832 {
    field RFU_TrainingCntr_r8 @0 {
       bits 16;
       access rw;
       reset 16'h0;
    }
  }
  register VrefDAC0_r8 @'h840 {
    field VrefDAC0_r8 @0 {
       bits 7;
       access rw;
       reset 7'h0;
    }
  }
  register TrainingIncDecDtsmEn_r8 @'h862 {
    field TrainingIncDecDtsmEn_r8 @0 {
       bits 9;
       access rw;
       reset 9'h0;
    }
  }
  register RxPBDlyTg0_r8 @'h868 {
    field RxPBDlyTg0_r8 @0 {
       bits 7;
       access rw;
       reset 7'h0;
    }
  }
  register RxPBDlyTg1_r8 @'h869 {
    field RxPBDlyTg1_r8 @0 {
       bits 7;
       access rw;
       reset 7'h0;
    }
  }
  register RxPBDlyTg2_r8 @'h86a {
    field RxPBDlyTg2_r8 @0 {
       bits 7;
       access rw;
       reset 7'h0;
    }
  }
  register RxPBDlyTg3_r8 @'h86b {
    field RxPBDlyTg3_r8 @0 {
       bits 7;
       access rw;
       reset 7'h0;
    }
  }
  register Tsm0_i8 @'h8b2 {
    field RFU_Tsm0_i8 @0 {
       bits 14;
       access rw;
       reset 14'h0;
    }
  }
  register Tsm1_i8 @'h8b3 {
    field RFU_Tsm1_i8 @0 {
       bits 16;
       access ro;
       reset 16'h0;
    }
  }
  register Tsm2_i8 @'h8b4 {
    field RFU_Tsm2_i8 @0 {
       bits 1;
       access rw;
       reset 1'h0;
    }
  }
  register TxDqDlyTg0_r8_p0 @'h8c0 {
    field TxDqDlyTg0_r8_p0 @0 {
       bits 9;
       access rw;
       reset 9'h10;
    }
  }
  register TxDqDlyTg1_r8_p0 @'h8c1 {
    field TxDqDlyTg1_r8_p0 @0 {
       bits 9;
       access rw;
       reset 9'h10;
    }
  }
  register TxDqDlyTg2_r8_p0 @'h8c2 {
    field TxDqDlyTg2_r8_p0 @0 {
       bits 9;
       access rw;
       reset 9'h10;
    }
  }
  register TxDqDlyTg3_r8_p0 @'h8c3 {
    field TxDqDlyTg3_r8_p0 @0 {
       bits 9;
       access rw;
       reset 9'h10;
    }
  }
  register UseDqsEnReplica_p1 @'h100003 {
    field UseDqsEnReplica_p1 @0 {
       bits 1;
       access rw;
       reset 1'h0;
    }
  }
  register DFIMRL_p1 @'h100020 {
    field DFIMRL_p1 @0 {
       bits 5;
       access rw;
       reset 5'h6;
    }
  }
  register TxImpedanceCtrl0_b0_p1 @'h100041 {
    field DrvStrenDqP @0 {
       bits 6;
       access rw;
       reset 6'h3f;
    }
    field DrvStrenDqN @6 {
       bits 6;
       access rw;
       reset 6'h3f;
    }
  }
  register DqDqsRcvCntrl_b0_p1 @'h100043 {
    field SelAnalogVref @0 {
       bits 1;
       access rw;
       reset 1'h0;
    }
    field ExtVrefRange @1 {
       bits 1;
       access rw;
       reset 1'h0;
    }
    field DfeCtrl @2 {
       bits 2;
       access rw;
       reset 2'h0;
    }
    field MajorModeDbyte @4 {
       bits 3;
       access rw;
       reset 3'h3;
    }
    field GainCurrAdj @7 {
       bits 5;
       access rw;
       reset 5'hb;
    }
    field Reserved @12 {
       bits 4;
    }
  }
  register TxEqualizationMode_p1 @'h100048 {
    field TxEqMode @0 {
       bits 2;
       access rw;
       reset 2'h0;
    }
  }
  register TxImpedanceCtrl1_b0_p1 @'h100049 {
    field DrvStrenFSDqP @0 {
       bits 6;
       access rw;
       reset 6'h3f;
    }
    field DrvStrenFSDqN @6 {
       bits 6;
       access rw;
       reset 6'h3f;
    }
  }
  register TxImpedanceCtrl2_b0_p1 @'h10004b {
    field DrvStrenEQHiDqP @0 {
       bits 6;
       access rw;
       reset 6'h0;
    }
    field DrvStrenEQLoDqN @6 {
       bits 6;
       access rw;
       reset 6'h0;
    }
  }
  register DqDqsRcvCntrl2_p1 @'h10004c {
    field EnRxAgressivePDR @0 {
       bits 1;
       access rw;
       reset 1'h0;
    }
  }
  register TxOdtDrvStren_b0_p1 @'h10004d {
    field ODTStrenP @0 {
       bits 6;
       access rw;
       reset 6'h0;
    }
    field ODTStrenN @6 {
       bits 6;
       access rw;
       reset 6'h0;
    }
  }
  register TxSlewRate_b0_p1 @'h10005f {
    field TxPreP @0 {
       bits 4;
       access rw;
       reset 4'hf;
    }
    field TxPreN @4 {
       bits 4;
       access rw;
       reset 4'hf;
    }
    field TxPreDrvMode @8 {
       bits 3;
       access rw;
       reset 3'h7;
    }
  }
  register RxEnDlyTg0_u0_p1 @'h100080 {
    field RxEnDlyTg0_u0_p1 @0 {
       bits 11;
       access rw;
       reset 11'h100;
    }
  }
  register RxEnDlyTg1_u0_p1 @'h100081 {
    field RxEnDlyTg1_u0_p1 @0 {
       bits 11;
       access rw;
       reset 11'h100;
    }
  }
  register RxEnDlyTg2_u0_p1 @'h100082 {
    field RxEnDlyTg2_u0_p1 @0 {
       bits 11;
       access rw;
       reset 11'h100;
    }
  }
  register RxEnDlyTg3_u0_p1 @'h100083 {
    field RxEnDlyTg3_u0_p1 @0 {
       bits 11;
       access rw;
       reset 11'h100;
    }
  }
  register RxClkDlyTg0_u0_p1 @'h10008c {
    field RxClkDlyTg0_u0_p1 @0 {
       bits 6;
       access rw;
       reset 6'h10;
    }
  }
  register RxClkDlyTg1_u0_p1 @'h10008d {
    field RxClkDlyTg1_u0_p1 @0 {
       bits 6;
       access rw;
       reset 6'h10;
    }
  }
  register RxClkDlyTg2_u0_p1 @'h10008e {
    field RxClkDlyTg2_u0_p1 @0 {
       bits 6;
       access rw;
       reset 6'h10;
    }
  }
  register RxClkDlyTg3_u0_p1 @'h10008f {
    field RxClkDlyTg3_u0_p1 @0 {
       bits 6;
       access rw;
       reset 6'h10;
    }
  }
  register RxClkcDlyTg0_u0_p1 @'h100090 {
    field RxClkcDlyTg0_u0_p1 @0 {
       bits 6;
       access rw;
       reset 6'h10;
    }
  }
  register RxClkcDlyTg1_u0_p1 @'h100091 {
    field RxClkcDlyTg1_u0_p1 @0 {
       bits 6;
       access rw;
       reset 6'h10;
    }
  }
  register RxClkcDlyTg2_u0_p1 @'h100092 {
    field RxClkcDlyTg2_u0_p1 @0 {
       bits 6;
       access rw;
       reset 6'h10;
    }
  }
  register RxClkcDlyTg3_u0_p1 @'h100093 {
    field RxClkcDlyTg3_u0_p1 @0 {
       bits 6;
       access rw;
       reset 6'h10;
    }
  }
  register PptDqsCntInvTrnTg0_p1 @'h1000ae {
    field PptDqsCntInvTrnTg0_p1 @0 {
       bits 16;
       access rw;
       reset 16'h0;
    }
  }
  register PptDqsCntInvTrnTg1_p1 @'h1000af {
    field PptDqsCntInvTrnTg1_p1 @0 {
       bits 16;
       access rw;
       reset 16'h0;
    }
  }
  register TxDqDlyTg0_r0_p1 @'h1000c0 {
    field TxDqDlyTg0_r0_p1 @0 {
       bits 9;
       access rw;
       reset 9'h10;
    }
  }
  register TxDqDlyTg1_r0_p1 @'h1000c1 {
    field TxDqDlyTg1_r0_p1 @0 {
       bits 9;
       access rw;
       reset 9'h10;
    }
  }
  register TxDqDlyTg2_r0_p1 @'h1000c2 {
    field TxDqDlyTg2_r0_p1 @0 {
       bits 9;
       access rw;
       reset 9'h10;
    }
  }
  register TxDqDlyTg3_r0_p1 @'h1000c3 {
    field TxDqDlyTg3_r0_p1 @0 {
       bits 9;
       access rw;
       reset 9'h10;
    }
  }
  register TxDqsDlyTg0_u0_p1 @'h1000d0 {
    field TxDqsDlyTg0_u0_p1 @0 {
       bits 10;
       access rw;
       reset 10'h100;
    }
  }
  register TxDqsDlyTg1_u0_p1 @'h1000d1 {
    field TxDqsDlyTg1_u0_p1 @0 {
       bits 10;
       access rw;
       reset 10'h100;
    }
  }
  register TxDqsDlyTg2_u0_p1 @'h1000d2 {
    field TxDqsDlyTg2_u0_p1 @0 {
       bits 10;
       access rw;
       reset 10'h100;
    }
  }
  register TxDqsDlyTg3_u0_p1 @'h1000d3 {
    field TxDqsDlyTg3_u0_p1 @0 {
       bits 10;
       access rw;
       reset 10'h100;
    }
  }
  register TxImpedanceCtrl0_b1_p1 @'h100141 {
    field DrvStrenDqP @0 {
       bits 6;
       access rw;
       reset 6'h3f;
    }
    field DrvStrenDqN @6 {
       bits 6;
       access rw;
       reset 6'h3f;
    }
  }
  register DqDqsRcvCntrl_b1_p1 @'h100143 {
    field SelAnalogVref @0 {
       bits 1;
       access rw;
       reset 1'h0;
    }
    field ExtVrefRange @1 {
       bits 1;
       access rw;
       reset 1'h0;
    }
    field DfeCtrl @2 {
       bits 2;
       access rw;
       reset 2'h0;
    }
    field MajorModeDbyte @4 {
       bits 3;
       access rw;
       reset 3'h3;
    }
    field GainCurrAdj @7 {
       bits 5;
       access rw;
       reset 5'hb;
    }
    field Reserved @12 {
       bits 4;
    }
  }
  register TxImpedanceCtrl1_b1_p1 @'h100149 {
    field DrvStrenFSDqP @0 {
       bits 6;
       access rw;
       reset 6'h3f;
    }
    field DrvStrenFSDqN @6 {
       bits 6;
       access rw;
       reset 6'h3f;
    }
  }
  register TxImpedanceCtrl2_b1_p1 @'h10014b {
    field DrvStrenEQHiDqP @0 {
       bits 6;
       access rw;
       reset 6'h0;
    }
    field DrvStrenEQLoDqN @6 {
       bits 6;
       access rw;
       reset 6'h0;
    }
  }
  register TxOdtDrvStren_b1_p1 @'h10014d {
    field ODTStrenP @0 {
       bits 6;
       access rw;
       reset 6'h0;
    }
    field ODTStrenN @6 {
       bits 6;
       access rw;
       reset 6'h0;
    }
  }
  register TxSlewRate_b1_p1 @'h10015f {
    field TxPreP @0 {
       bits 4;
       access rw;
       reset 4'hf;
    }
    field TxPreN @4 {
       bits 4;
       access rw;
       reset 4'hf;
    }
    field TxPreDrvMode @8 {
       bits 3;
       access rw;
       reset 3'h7;
    }
  }
  register RxEnDlyTg0_u1_p1 @'h100180 {
    field RxEnDlyTg0_u1_p1 @0 {
       bits 11;
       access rw;
       reset 11'h100;
    }
  }
  register RxEnDlyTg1_u1_p1 @'h100181 {
    field RxEnDlyTg1_u1_p1 @0 {
       bits 11;
       access rw;
       reset 11'h100;
    }
  }
  register RxEnDlyTg2_u1_p1 @'h100182 {
    field RxEnDlyTg2_u1_p1 @0 {
       bits 11;
       access rw;
       reset 11'h100;
    }
  }
  register RxEnDlyTg3_u1_p1 @'h100183 {
    field RxEnDlyTg3_u1_p1 @0 {
       bits 11;
       access rw;
       reset 11'h100;
    }
  }
  register RxClkDlyTg0_u1_p1 @'h10018c {
    field RxClkDlyTg0_u1_p1 @0 {
       bits 6;
       access rw;
       reset 6'h10;
    }
  }
  register RxClkDlyTg1_u1_p1 @'h10018d {
    field RxClkDlyTg1_u1_p1 @0 {
       bits 6;
       access rw;
       reset 6'h10;
    }
  }
  register RxClkDlyTg2_u1_p1 @'h10018e {
    field RxClkDlyTg2_u1_p1 @0 {
       bits 6;
       access rw;
       reset 6'h10;
    }
  }
  register RxClkDlyTg3_u1_p1 @'h10018f {
    field RxClkDlyTg3_u1_p1 @0 {
       bits 6;
       access rw;
       reset 6'h10;
    }
  }
  register RxClkcDlyTg0_u1_p1 @'h100190 {
    field RxClkcDlyTg0_u1_p1 @0 {
       bits 6;
       access rw;
       reset 6'h10;
    }
  }
  register RxClkcDlyTg1_u1_p1 @'h100191 {
    field RxClkcDlyTg1_u1_p1 @0 {
       bits 6;
       access rw;
       reset 6'h10;
    }
  }
  register RxClkcDlyTg2_u1_p1 @'h100192 {
    field RxClkcDlyTg2_u1_p1 @0 {
       bits 6;
       access rw;
       reset 6'h10;
    }
  }
  register RxClkcDlyTg3_u1_p1 @'h100193 {
    field RxClkcDlyTg3_u1_p1 @0 {
       bits 6;
       access rw;
       reset 6'h10;
    }
  }
  register TxDqDlyTg0_r1_p1 @'h1001c0 {
    field TxDqDlyTg0_r1_p1 @0 {
       bits 9;
       access rw;
       reset 9'h10;
    }
  }
  register TxDqDlyTg1_r1_p1 @'h1001c1 {
    field TxDqDlyTg1_r1_p1 @0 {
       bits 9;
       access rw;
       reset 9'h10;
    }
  }
  register TxDqDlyTg2_r1_p1 @'h1001c2 {
    field TxDqDlyTg2_r1_p1 @0 {
       bits 9;
       access rw;
       reset 9'h10;
    }
  }
  register TxDqDlyTg3_r1_p1 @'h1001c3 {
    field TxDqDlyTg3_r1_p1 @0 {
       bits 9;
       access rw;
       reset 9'h10;
    }
  }
  register TxDqsDlyTg0_u1_p1 @'h1001d0 {
    field TxDqsDlyTg0_u1_p1 @0 {
       bits 10;
       access rw;
       reset 10'h100;
    }
  }
  register TxDqsDlyTg1_u1_p1 @'h1001d1 {
    field TxDqsDlyTg1_u1_p1 @0 {
       bits 10;
       access rw;
       reset 10'h100;
    }
  }
  register TxDqsDlyTg2_u1_p1 @'h1001d2 {
    field TxDqsDlyTg2_u1_p1 @0 {
       bits 10;
       access rw;
       reset 10'h100;
    }
  }
  register TxDqsDlyTg3_u1_p1 @'h1001d3 {
    field TxDqsDlyTg3_u1_p1 @0 {
       bits 10;
       access rw;
       reset 10'h100;
    }
  }
  register TxDqDlyTg0_r2_p1 @'h1002c0 {
    field TxDqDlyTg0_r2_p1 @0 {
       bits 9;
       access rw;
       reset 9'h10;
    }
  }
  register TxDqDlyTg1_r2_p1 @'h1002c1 {
    field TxDqDlyTg1_r2_p1 @0 {
       bits 9;
       access rw;
       reset 9'h10;
    }
  }
  register TxDqDlyTg2_r2_p1 @'h1002c2 {
    field TxDqDlyTg2_r2_p1 @0 {
       bits 9;
       access rw;
       reset 9'h10;
    }
  }
  register TxDqDlyTg3_r2_p1 @'h1002c3 {
    field TxDqDlyTg3_r2_p1 @0 {
       bits 9;
       access rw;
       reset 9'h10;
    }
  }
  register TxDqDlyTg0_r3_p1 @'h1003c0 {
    field TxDqDlyTg0_r3_p1 @0 {
       bits 9;
       access rw;
       reset 9'h10;
    }
  }
  register TxDqDlyTg1_r3_p1 @'h1003c1 {
    field TxDqDlyTg1_r3_p1 @0 {
       bits 9;
       access rw;
       reset 9'h10;
    }
  }
  register TxDqDlyTg2_r3_p1 @'h1003c2 {
    field TxDqDlyTg2_r3_p1 @0 {
       bits 9;
       access rw;
       reset 9'h10;
    }
  }
  register TxDqDlyTg3_r3_p1 @'h1003c3 {
    field TxDqDlyTg3_r3_p1 @0 {
       bits 9;
       access rw;
       reset 9'h10;
    }
  }
  register TxDqDlyTg0_r4_p1 @'h1004c0 {
    field TxDqDlyTg0_r4_p1 @0 {
       bits 9;
       access rw;
       reset 9'h10;
    }
  }
  register TxDqDlyTg1_r4_p1 @'h1004c1 {
    field TxDqDlyTg1_r4_p1 @0 {
       bits 9;
       access rw;
       reset 9'h10;
    }
  }
  register TxDqDlyTg2_r4_p1 @'h1004c2 {
    field TxDqDlyTg2_r4_p1 @0 {
       bits 9;
       access rw;
       reset 9'h10;
    }
  }
  register TxDqDlyTg3_r4_p1 @'h1004c3 {
    field TxDqDlyTg3_r4_p1 @0 {
       bits 9;
       access rw;
       reset 9'h10;
    }
  }
  register TxDqDlyTg0_r5_p1 @'h1005c0 {
    field TxDqDlyTg0_r5_p1 @0 {
       bits 9;
       access rw;
       reset 9'h10;
    }
  }
  register TxDqDlyTg1_r5_p1 @'h1005c1 {
    field TxDqDlyTg1_r5_p1 @0 {
       bits 9;
       access rw;
       reset 9'h10;
    }
  }
  register TxDqDlyTg2_r5_p1 @'h1005c2 {
    field TxDqDlyTg2_r5_p1 @0 {
       bits 9;
       access rw;
       reset 9'h10;
    }
  }
  register TxDqDlyTg3_r5_p1 @'h1005c3 {
    field TxDqDlyTg3_r5_p1 @0 {
       bits 9;
       access rw;
       reset 9'h10;
    }
  }
  register TxDqDlyTg0_r6_p1 @'h1006c0 {
    field TxDqDlyTg0_r6_p1 @0 {
       bits 9;
       access rw;
       reset 9'h10;
    }
  }
  register TxDqDlyTg1_r6_p1 @'h1006c1 {
    field TxDqDlyTg1_r6_p1 @0 {
       bits 9;
       access rw;
       reset 9'h10;
    }
  }
  register TxDqDlyTg2_r6_p1 @'h1006c2 {
    field TxDqDlyTg2_r6_p1 @0 {
       bits 9;
       access rw;
       reset 9'h10;
    }
  }
  register TxDqDlyTg3_r6_p1 @'h1006c3 {
    field TxDqDlyTg3_r6_p1 @0 {
       bits 9;
       access rw;
       reset 9'h10;
    }
  }
  register TxDqDlyTg0_r7_p1 @'h1007c0 {
    field TxDqDlyTg0_r7_p1 @0 {
       bits 9;
       access rw;
       reset 9'h10;
    }
  }
  register TxDqDlyTg1_r7_p1 @'h1007c1 {
    field TxDqDlyTg1_r7_p1 @0 {
       bits 9;
       access rw;
       reset 9'h10;
    }
  }
  register TxDqDlyTg2_r7_p1 @'h1007c2 {
    field TxDqDlyTg2_r7_p1 @0 {
       bits 9;
       access rw;
       reset 9'h10;
    }
  }
  register TxDqDlyTg3_r7_p1 @'h1007c3 {
    field TxDqDlyTg3_r7_p1 @0 {
       bits 9;
       access rw;
       reset 9'h10;
    }
  }
  register TxDqDlyTg0_r8_p1 @'h1008c0 {
    field TxDqDlyTg0_r8_p1 @0 {
       bits 9;
       access rw;
       reset 9'h10;
    }
  }
  register TxDqDlyTg1_r8_p1 @'h1008c1 {
    field TxDqDlyTg1_r8_p1 @0 {
       bits 9;
       access rw;
       reset 9'h10;
    }
  }
  register TxDqDlyTg2_r8_p1 @'h1008c2 {
    field TxDqDlyTg2_r8_p1 @0 {
       bits 9;
       access rw;
       reset 9'h10;
    }
  }
  register TxDqDlyTg3_r8_p1 @'h1008c3 {
    field TxDqDlyTg3_r8_p1 @0 {
       bits 9;
       access rw;
       reset 9'h10;
    }
  }
  register UseDqsEnReplica_p2 @'h200003 {
    field UseDqsEnReplica_p2 @0 {
       bits 1;
       access rw;
       reset 1'h0;
    }
  }
  register DFIMRL_p2 @'h200020 {
    field DFIMRL_p2 @0 {
       bits 5;
       access rw;
       reset 5'h6;
    }
  }
  register TxImpedanceCtrl0_b0_p2 @'h200041 {
    field DrvStrenDqP @0 {
       bits 6;
       access rw;
       reset 6'h3f;
    }
    field DrvStrenDqN @6 {
       bits 6;
       access rw;
       reset 6'h3f;
    }
  }
  register DqDqsRcvCntrl_b0_p2 @'h200043 {
    field SelAnalogVref @0 {
       bits 1;
       access rw;
       reset 1'h0;
    }
    field ExtVrefRange @1 {
       bits 1;
       access rw;
       reset 1'h0;
    }
    field DfeCtrl @2 {
       bits 2;
       access rw;
       reset 2'h0;
    }
    field MajorModeDbyte @4 {
       bits 3;
       access rw;
       reset 3'h3;
    }
    field GainCurrAdj @7 {
       bits 5;
       access rw;
       reset 5'hb;
    }
    field Reserved @12 {
       bits 4;
    }
  }
  register TxEqualizationMode_p2 @'h200048 {
    field TxEqMode @0 {
       bits 2;
       access rw;
       reset 2'h0;
    }
  }
  register TxImpedanceCtrl1_b0_p2 @'h200049 {
    field DrvStrenFSDqP @0 {
       bits 6;
       access rw;
       reset 6'h3f;
    }
    field DrvStrenFSDqN @6 {
       bits 6;
       access rw;
       reset 6'h3f;
    }
  }
  register TxImpedanceCtrl2_b0_p2 @'h20004b {
    field DrvStrenEQHiDqP @0 {
       bits 6;
       access rw;
       reset 6'h0;
    }
    field DrvStrenEQLoDqN @6 {
       bits 6;
       access rw;
       reset 6'h0;
    }
  }
  register DqDqsRcvCntrl2_p2 @'h20004c {
    field EnRxAgressivePDR @0 {
       bits 1;
       access rw;
       reset 1'h0;
    }
  }
  register TxOdtDrvStren_b0_p2 @'h20004d {
    field ODTStrenP @0 {
       bits 6;
       access rw;
       reset 6'h0;
    }
    field ODTStrenN @6 {
       bits 6;
       access rw;
       reset 6'h0;
    }
  }
  register TxSlewRate_b0_p2 @'h20005f {
    field TxPreP @0 {
       bits 4;
       access rw;
       reset 4'hf;
    }
    field TxPreN @4 {
       bits 4;
       access rw;
       reset 4'hf;
    }
    field TxPreDrvMode @8 {
       bits 3;
       access rw;
       reset 3'h7;
    }
  }
  register RxEnDlyTg0_u0_p2 @'h200080 {
    field RxEnDlyTg0_u0_p2 @0 {
       bits 11;
       access rw;
       reset 11'h100;
    }
  }
  register RxEnDlyTg1_u0_p2 @'h200081 {
    field RxEnDlyTg1_u0_p2 @0 {
       bits 11;
       access rw;
       reset 11'h100;
    }
  }
  register RxEnDlyTg2_u0_p2 @'h200082 {
    field RxEnDlyTg2_u0_p2 @0 {
       bits 11;
       access rw;
       reset 11'h100;
    }
  }
  register RxEnDlyTg3_u0_p2 @'h200083 {
    field RxEnDlyTg3_u0_p2 @0 {
       bits 11;
       access rw;
       reset 11'h100;
    }
  }
  register RxClkDlyTg0_u0_p2 @'h20008c {
    field RxClkDlyTg0_u0_p2 @0 {
       bits 6;
       access rw;
       reset 6'h10;
    }
  }
  register RxClkDlyTg1_u0_p2 @'h20008d {
    field RxClkDlyTg1_u0_p2 @0 {
       bits 6;
       access rw;
       reset 6'h10;
    }
  }
  register RxClkDlyTg2_u0_p2 @'h20008e {
    field RxClkDlyTg2_u0_p2 @0 {
       bits 6;
       access rw;
       reset 6'h10;
    }
  }
  register RxClkDlyTg3_u0_p2 @'h20008f {
    field RxClkDlyTg3_u0_p2 @0 {
       bits 6;
       access rw;
       reset 6'h10;
    }
  }
  register RxClkcDlyTg0_u0_p2 @'h200090 {
    field RxClkcDlyTg0_u0_p2 @0 {
       bits 6;
       access rw;
       reset 6'h10;
    }
  }
  register RxClkcDlyTg1_u0_p2 @'h200091 {
    field RxClkcDlyTg1_u0_p2 @0 {
       bits 6;
       access rw;
       reset 6'h10;
    }
  }
  register RxClkcDlyTg2_u0_p2 @'h200092 {
    field RxClkcDlyTg2_u0_p2 @0 {
       bits 6;
       access rw;
       reset 6'h10;
    }
  }
  register RxClkcDlyTg3_u0_p2 @'h200093 {
    field RxClkcDlyTg3_u0_p2 @0 {
       bits 6;
       access rw;
       reset 6'h10;
    }
  }
  register PptDqsCntInvTrnTg0_p2 @'h2000ae {
    field PptDqsCntInvTrnTg0_p2 @0 {
       bits 16;
       access rw;
       reset 16'h0;
    }
  }
  register PptDqsCntInvTrnTg1_p2 @'h2000af {
    field PptDqsCntInvTrnTg1_p2 @0 {
       bits 16;
       access rw;
       reset 16'h0;
    }
  }
  register TxDqDlyTg0_r0_p2 @'h2000c0 {
    field TxDqDlyTg0_r0_p2 @0 {
       bits 9;
       access rw;
       reset 9'h10;
    }
  }
  register TxDqDlyTg1_r0_p2 @'h2000c1 {
    field TxDqDlyTg1_r0_p2 @0 {
       bits 9;
       access rw;
       reset 9'h10;
    }
  }
  register TxDqDlyTg2_r0_p2 @'h2000c2 {
    field TxDqDlyTg2_r0_p2 @0 {
       bits 9;
       access rw;
       reset 9'h10;
    }
  }
  register TxDqDlyTg3_r0_p2 @'h2000c3 {
    field TxDqDlyTg3_r0_p2 @0 {
       bits 9;
       access rw;
       reset 9'h10;
    }
  }
  register TxDqsDlyTg0_u0_p2 @'h2000d0 {
    field TxDqsDlyTg0_u0_p2 @0 {
       bits 10;
       access rw;
       reset 10'h100;
    }
  }
  register TxDqsDlyTg1_u0_p2 @'h2000d1 {
    field TxDqsDlyTg1_u0_p2 @0 {
       bits 10;
       access rw;
       reset 10'h100;
    }
  }
  register TxDqsDlyTg2_u0_p2 @'h2000d2 {
    field TxDqsDlyTg2_u0_p2 @0 {
       bits 10;
       access rw;
       reset 10'h100;
    }
  }
  register TxDqsDlyTg3_u0_p2 @'h2000d3 {
    field TxDqsDlyTg3_u0_p2 @0 {
       bits 10;
       access rw;
       reset 10'h100;
    }
  }
  register TxImpedanceCtrl0_b1_p2 @'h200141 {
    field DrvStrenDqP @0 {
       bits 6;
       access rw;
       reset 6'h3f;
    }
    field DrvStrenDqN @6 {
       bits 6;
       access rw;
       reset 6'h3f;
    }
  }
  register DqDqsRcvCntrl_b1_p2 @'h200143 {
    field SelAnalogVref @0 {
       bits 1;
       access rw;
       reset 1'h0;
    }
    field ExtVrefRange @1 {
       bits 1;
       access rw;
       reset 1'h0;
    }
    field DfeCtrl @2 {
       bits 2;
       access rw;
       reset 2'h0;
    }
    field MajorModeDbyte @4 {
       bits 3;
       access rw;
       reset 3'h3;
    }
    field GainCurrAdj @7 {
       bits 5;
       access rw;
       reset 5'hb;
    }
    field Reserved @12 {
       bits 4;
    }
  }
  register TxImpedanceCtrl1_b1_p2 @'h200149 {
    field DrvStrenFSDqP @0 {
       bits 6;
       access rw;
       reset 6'h3f;
    }
    field DrvStrenFSDqN @6 {
       bits 6;
       access rw;
       reset 6'h3f;
    }
  }
  register TxImpedanceCtrl2_b1_p2 @'h20014b {
    field DrvStrenEQHiDqP @0 {
       bits 6;
       access rw;
       reset 6'h0;
    }
    field DrvStrenEQLoDqN @6 {
       bits 6;
       access rw;
       reset 6'h0;
    }
  }
  register TxOdtDrvStren_b1_p2 @'h20014d {
    field ODTStrenP @0 {
       bits 6;
       access rw;
       reset 6'h0;
    }
    field ODTStrenN @6 {
       bits 6;
       access rw;
       reset 6'h0;
    }
  }
  register TxSlewRate_b1_p2 @'h20015f {
    field TxPreP @0 {
       bits 4;
       access rw;
       reset 4'hf;
    }
    field TxPreN @4 {
       bits 4;
       access rw;
       reset 4'hf;
    }
    field TxPreDrvMode @8 {
       bits 3;
       access rw;
       reset 3'h7;
    }
  }
  register RxEnDlyTg0_u1_p2 @'h200180 {
    field RxEnDlyTg0_u1_p2 @0 {
       bits 11;
       access rw;
       reset 11'h100;
    }
  }
  register RxEnDlyTg1_u1_p2 @'h200181 {
    field RxEnDlyTg1_u1_p2 @0 {
       bits 11;
       access rw;
       reset 11'h100;
    }
  }
  register RxEnDlyTg2_u1_p2 @'h200182 {
    field RxEnDlyTg2_u1_p2 @0 {
       bits 11;
       access rw;
       reset 11'h100;
    }
  }
  register RxEnDlyTg3_u1_p2 @'h200183 {
    field RxEnDlyTg3_u1_p2 @0 {
       bits 11;
       access rw;
       reset 11'h100;
    }
  }
  register RxClkDlyTg0_u1_p2 @'h20018c {
    field RxClkDlyTg0_u1_p2 @0 {
       bits 6;
       access rw;
       reset 6'h10;
    }
  }
  register RxClkDlyTg1_u1_p2 @'h20018d {
    field RxClkDlyTg1_u1_p2 @0 {
       bits 6;
       access rw;
       reset 6'h10;
    }
  }
  register RxClkDlyTg2_u1_p2 @'h20018e {
    field RxClkDlyTg2_u1_p2 @0 {
       bits 6;
       access rw;
       reset 6'h10;
    }
  }
  register RxClkDlyTg3_u1_p2 @'h20018f {
    field RxClkDlyTg3_u1_p2 @0 {
       bits 6;
       access rw;
       reset 6'h10;
    }
  }
  register RxClkcDlyTg0_u1_p2 @'h200190 {
    field RxClkcDlyTg0_u1_p2 @0 {
       bits 6;
       access rw;
       reset 6'h10;
    }
  }
  register RxClkcDlyTg1_u1_p2 @'h200191 {
    field RxClkcDlyTg1_u1_p2 @0 {
       bits 6;
       access rw;
       reset 6'h10;
    }
  }
  register RxClkcDlyTg2_u1_p2 @'h200192 {
    field RxClkcDlyTg2_u1_p2 @0 {
       bits 6;
       access rw;
       reset 6'h10;
    }
  }
  register RxClkcDlyTg3_u1_p2 @'h200193 {
    field RxClkcDlyTg3_u1_p2 @0 {
       bits 6;
       access rw;
       reset 6'h10;
    }
  }
  register TxDqDlyTg0_r1_p2 @'h2001c0 {
    field TxDqDlyTg0_r1_p2 @0 {
       bits 9;
       access rw;
       reset 9'h10;
    }
  }
  register TxDqDlyTg1_r1_p2 @'h2001c1 {
    field TxDqDlyTg1_r1_p2 @0 {
       bits 9;
       access rw;
       reset 9'h10;
    }
  }
  register TxDqDlyTg2_r1_p2 @'h2001c2 {
    field TxDqDlyTg2_r1_p2 @0 {
       bits 9;
       access rw;
       reset 9'h10;
    }
  }
  register TxDqDlyTg3_r1_p2 @'h2001c3 {
    field TxDqDlyTg3_r1_p2 @0 {
       bits 9;
       access rw;
       reset 9'h10;
    }
  }
  register TxDqsDlyTg0_u1_p2 @'h2001d0 {
    field TxDqsDlyTg0_u1_p2 @0 {
       bits 10;
       access rw;
       reset 10'h100;
    }
  }
  register TxDqsDlyTg1_u1_p2 @'h2001d1 {
    field TxDqsDlyTg1_u1_p2 @0 {
       bits 10;
       access rw;
       reset 10'h100;
    }
  }
  register TxDqsDlyTg2_u1_p2 @'h2001d2 {
    field TxDqsDlyTg2_u1_p2 @0 {
       bits 10;
       access rw;
       reset 10'h100;
    }
  }
  register TxDqsDlyTg3_u1_p2 @'h2001d3 {
    field TxDqsDlyTg3_u1_p2 @0 {
       bits 10;
       access rw;
       reset 10'h100;
    }
  }
  register TxDqDlyTg0_r2_p2 @'h2002c0 {
    field TxDqDlyTg0_r2_p2 @0 {
       bits 9;
       access rw;
       reset 9'h10;
    }
  }
  register TxDqDlyTg1_r2_p2 @'h2002c1 {
    field TxDqDlyTg1_r2_p2 @0 {
       bits 9;
       access rw;
       reset 9'h10;
    }
  }
  register TxDqDlyTg2_r2_p2 @'h2002c2 {
    field TxDqDlyTg2_r2_p2 @0 {
       bits 9;
       access rw;
       reset 9'h10;
    }
  }
  register TxDqDlyTg3_r2_p2 @'h2002c3 {
    field TxDqDlyTg3_r2_p2 @0 {
       bits 9;
       access rw;
       reset 9'h10;
    }
  }
  register TxDqDlyTg0_r3_p2 @'h2003c0 {
    field TxDqDlyTg0_r3_p2 @0 {
       bits 9;
       access rw;
       reset 9'h10;
    }
  }
  register TxDqDlyTg1_r3_p2 @'h2003c1 {
    field TxDqDlyTg1_r3_p2 @0 {
       bits 9;
       access rw;
       reset 9'h10;
    }
  }
  register TxDqDlyTg2_r3_p2 @'h2003c2 {
    field TxDqDlyTg2_r3_p2 @0 {
       bits 9;
       access rw;
       reset 9'h10;
    }
  }
  register TxDqDlyTg3_r3_p2 @'h2003c3 {
    field TxDqDlyTg3_r3_p2 @0 {
       bits 9;
       access rw;
       reset 9'h10;
    }
  }
  register TxDqDlyTg0_r4_p2 @'h2004c0 {
    field TxDqDlyTg0_r4_p2 @0 {
       bits 9;
       access rw;
       reset 9'h10;
    }
  }
  register TxDqDlyTg1_r4_p2 @'h2004c1 {
    field TxDqDlyTg1_r4_p2 @0 {
       bits 9;
       access rw;
       reset 9'h10;
    }
  }
  register TxDqDlyTg2_r4_p2 @'h2004c2 {
    field TxDqDlyTg2_r4_p2 @0 {
       bits 9;
       access rw;
       reset 9'h10;
    }
  }
  register TxDqDlyTg3_r4_p2 @'h2004c3 {
    field TxDqDlyTg3_r4_p2 @0 {
       bits 9;
       access rw;
       reset 9'h10;
    }
  }
  register TxDqDlyTg0_r5_p2 @'h2005c0 {
    field TxDqDlyTg0_r5_p2 @0 {
       bits 9;
       access rw;
       reset 9'h10;
    }
  }
  register TxDqDlyTg1_r5_p2 @'h2005c1 {
    field TxDqDlyTg1_r5_p2 @0 {
       bits 9;
       access rw;
       reset 9'h10;
    }
  }
  register TxDqDlyTg2_r5_p2 @'h2005c2 {
    field TxDqDlyTg2_r5_p2 @0 {
       bits 9;
       access rw;
       reset 9'h10;
    }
  }
  register TxDqDlyTg3_r5_p2 @'h2005c3 {
    field TxDqDlyTg3_r5_p2 @0 {
       bits 9;
       access rw;
       reset 9'h10;
    }
  }
  register TxDqDlyTg0_r6_p2 @'h2006c0 {
    field TxDqDlyTg0_r6_p2 @0 {
       bits 9;
       access rw;
       reset 9'h10;
    }
  }
  register TxDqDlyTg1_r6_p2 @'h2006c1 {
    field TxDqDlyTg1_r6_p2 @0 {
       bits 9;
       access rw;
       reset 9'h10;
    }
  }
  register TxDqDlyTg2_r6_p2 @'h2006c2 {
    field TxDqDlyTg2_r6_p2 @0 {
       bits 9;
       access rw;
       reset 9'h10;
    }
  }
  register TxDqDlyTg3_r6_p2 @'h2006c3 {
    field TxDqDlyTg3_r6_p2 @0 {
       bits 9;
       access rw;
       reset 9'h10;
    }
  }
  register TxDqDlyTg0_r7_p2 @'h2007c0 {
    field TxDqDlyTg0_r7_p2 @0 {
       bits 9;
       access rw;
       reset 9'h10;
    }
  }
  register TxDqDlyTg1_r7_p2 @'h2007c1 {
    field TxDqDlyTg1_r7_p2 @0 {
       bits 9;
       access rw;
       reset 9'h10;
    }
  }
  register TxDqDlyTg2_r7_p2 @'h2007c2 {
    field TxDqDlyTg2_r7_p2 @0 {
       bits 9;
       access rw;
       reset 9'h10;
    }
  }
  register TxDqDlyTg3_r7_p2 @'h2007c3 {
    field TxDqDlyTg3_r7_p2 @0 {
       bits 9;
       access rw;
       reset 9'h10;
    }
  }
  register TxDqDlyTg0_r8_p2 @'h2008c0 {
    field TxDqDlyTg0_r8_p2 @0 {
       bits 9;
       access rw;
       reset 9'h10;
    }
  }
  register TxDqDlyTg1_r8_p2 @'h2008c1 {
    field TxDqDlyTg1_r8_p2 @0 {
       bits 9;
       access rw;
       reset 9'h10;
    }
  }
  register TxDqDlyTg2_r8_p2 @'h2008c2 {
    field TxDqDlyTg2_r8_p2 @0 {
       bits 9;
       access rw;
       reset 9'h10;
    }
  }
  register TxDqDlyTg3_r8_p2 @'h2008c3 {
    field TxDqDlyTg3_r8_p2 @0 {
       bits 9;
       access rw;
       reset 9'h10;
    }
  }
  register UseDqsEnReplica_p3 @'h300003 {
    field UseDqsEnReplica_p3 @0 {
       bits 1;
       access rw;
       reset 1'h0;
    }
  }
  register DFIMRL_p3 @'h300020 {
    field DFIMRL_p3 @0 {
       bits 5;
       access rw;
       reset 5'h6;
    }
  }
  register TxImpedanceCtrl0_b0_p3 @'h300041 {
    field DrvStrenDqP @0 {
       bits 6;
       access rw;
       reset 6'h3f;
    }
    field DrvStrenDqN @6 {
       bits 6;
       access rw;
       reset 6'h3f;
    }
  }
  register DqDqsRcvCntrl_b0_p3 @'h300043 {
    field SelAnalogVref @0 {
       bits 1;
       access rw;
       reset 1'h0;
    }
    field ExtVrefRange @1 {
       bits 1;
       access rw;
       reset 1'h0;
    }
    field DfeCtrl @2 {
       bits 2;
       access rw;
       reset 2'h0;
    }
    field MajorModeDbyte @4 {
       bits 3;
       access rw;
       reset 3'h3;
    }
    field GainCurrAdj @7 {
       bits 5;
       access rw;
       reset 5'hb;
    }
    field Reserved @12 {
       bits 4;
    }
  }
  register TxEqualizationMode_p3 @'h300048 {
    field TxEqMode @0 {
       bits 2;
       access rw;
       reset 2'h0;
    }
  }
  register TxImpedanceCtrl1_b0_p3 @'h300049 {
    field DrvStrenFSDqP @0 {
       bits 6;
       access rw;
       reset 6'h3f;
    }
    field DrvStrenFSDqN @6 {
       bits 6;
       access rw;
       reset 6'h3f;
    }
  }
  register TxImpedanceCtrl2_b0_p3 @'h30004b {
    field DrvStrenEQHiDqP @0 {
       bits 6;
       access rw;
       reset 6'h0;
    }
    field DrvStrenEQLoDqN @6 {
       bits 6;
       access rw;
       reset 6'h0;
    }
  }
  register DqDqsRcvCntrl2_p3 @'h30004c {
    field EnRxAgressivePDR @0 {
       bits 1;
       access rw;
       reset 1'h0;
    }
  }
  register TxOdtDrvStren_b0_p3 @'h30004d {
    field ODTStrenP @0 {
       bits 6;
       access rw;
       reset 6'h0;
    }
    field ODTStrenN @6 {
       bits 6;
       access rw;
       reset 6'h0;
    }
  }
  register TxSlewRate_b0_p3 @'h30005f {
    field TxPreP @0 {
       bits 4;
       access rw;
       reset 4'hf;
    }
    field TxPreN @4 {
       bits 4;
       access rw;
       reset 4'hf;
    }
    field TxPreDrvMode @8 {
       bits 3;
       access rw;
       reset 3'h7;
    }
  }
  register RxEnDlyTg0_u0_p3 @'h300080 {
    field RxEnDlyTg0_u0_p3 @0 {
       bits 11;
       access rw;
       reset 11'h100;
    }
  }
  register RxEnDlyTg1_u0_p3 @'h300081 {
    field RxEnDlyTg1_u0_p3 @0 {
       bits 11;
       access rw;
       reset 11'h100;
    }
  }
  register RxEnDlyTg2_u0_p3 @'h300082 {
    field RxEnDlyTg2_u0_p3 @0 {
       bits 11;
       access rw;
       reset 11'h100;
    }
  }
  register RxEnDlyTg3_u0_p3 @'h300083 {
    field RxEnDlyTg3_u0_p3 @0 {
       bits 11;
       access rw;
       reset 11'h100;
    }
  }
  register RxClkDlyTg0_u0_p3 @'h30008c {
    field RxClkDlyTg0_u0_p3 @0 {
       bits 6;
       access rw;
       reset 6'h10;
    }
  }
  register RxClkDlyTg1_u0_p3 @'h30008d {
    field RxClkDlyTg1_u0_p3 @0 {
       bits 6;
       access rw;
       reset 6'h10;
    }
  }
  register RxClkDlyTg2_u0_p3 @'h30008e {
    field RxClkDlyTg2_u0_p3 @0 {
       bits 6;
       access rw;
       reset 6'h10;
    }
  }
  register RxClkDlyTg3_u0_p3 @'h30008f {
    field RxClkDlyTg3_u0_p3 @0 {
       bits 6;
       access rw;
       reset 6'h10;
    }
  }
  register RxClkcDlyTg0_u0_p3 @'h300090 {
    field RxClkcDlyTg0_u0_p3 @0 {
       bits 6;
       access rw;
       reset 6'h10;
    }
  }
  register RxClkcDlyTg1_u0_p3 @'h300091 {
    field RxClkcDlyTg1_u0_p3 @0 {
       bits 6;
       access rw;
       reset 6'h10;
    }
  }
  register RxClkcDlyTg2_u0_p3 @'h300092 {
    field RxClkcDlyTg2_u0_p3 @0 {
       bits 6;
       access rw;
       reset 6'h10;
    }
  }
  register RxClkcDlyTg3_u0_p3 @'h300093 {
    field RxClkcDlyTg3_u0_p3 @0 {
       bits 6;
       access rw;
       reset 6'h10;
    }
  }
  register PptDqsCntInvTrnTg0_p3 @'h3000ae {
    field PptDqsCntInvTrnTg0_p3 @0 {
       bits 16;
       access rw;
       reset 16'h0;
    }
  }
  register PptDqsCntInvTrnTg1_p3 @'h3000af {
    field PptDqsCntInvTrnTg1_p3 @0 {
       bits 16;
       access rw;
       reset 16'h0;
    }
  }
  register TxDqDlyTg0_r0_p3 @'h3000c0 {
    field TxDqDlyTg0_r0_p3 @0 {
       bits 9;
       access rw;
       reset 9'h10;
    }
  }
  register TxDqDlyTg1_r0_p3 @'h3000c1 {
    field TxDqDlyTg1_r0_p3 @0 {
       bits 9;
       access rw;
       reset 9'h10;
    }
  }
  register TxDqDlyTg2_r0_p3 @'h3000c2 {
    field TxDqDlyTg2_r0_p3 @0 {
       bits 9;
       access rw;
       reset 9'h10;
    }
  }
  register TxDqDlyTg3_r0_p3 @'h3000c3 {
    field TxDqDlyTg3_r0_p3 @0 {
       bits 9;
       access rw;
       reset 9'h10;
    }
  }
  register TxDqsDlyTg0_u0_p3 @'h3000d0 {
    field TxDqsDlyTg0_u0_p3 @0 {
       bits 10;
       access rw;
       reset 10'h100;
    }
  }
  register TxDqsDlyTg1_u0_p3 @'h3000d1 {
    field TxDqsDlyTg1_u0_p3 @0 {
       bits 10;
       access rw;
       reset 10'h100;
    }
  }
  register TxDqsDlyTg2_u0_p3 @'h3000d2 {
    field TxDqsDlyTg2_u0_p3 @0 {
       bits 10;
       access rw;
       reset 10'h100;
    }
  }
  register TxDqsDlyTg3_u0_p3 @'h3000d3 {
    field TxDqsDlyTg3_u0_p3 @0 {
       bits 10;
       access rw;
       reset 10'h100;
    }
  }
  register TxImpedanceCtrl0_b1_p3 @'h300141 {
    field DrvStrenDqP @0 {
       bits 6;
       access rw;
       reset 6'h3f;
    }
    field DrvStrenDqN @6 {
       bits 6;
       access rw;
       reset 6'h3f;
    }
  }
  register DqDqsRcvCntrl_b1_p3 @'h300143 {
    field SelAnalogVref @0 {
       bits 1;
       access rw;
       reset 1'h0;
    }
    field ExtVrefRange @1 {
       bits 1;
       access rw;
       reset 1'h0;
    }
    field DfeCtrl @2 {
       bits 2;
       access rw;
       reset 2'h0;
    }
    field MajorModeDbyte @4 {
       bits 3;
       access rw;
       reset 3'h3;
    }
    field GainCurrAdj @7 {
       bits 5;
       access rw;
       reset 5'hb;
    }
    field Reserved @12 {
       bits 4;
    }
  }
  register TxImpedanceCtrl1_b1_p3 @'h300149 {
    field DrvStrenFSDqP @0 {
       bits 6;
       access rw;
       reset 6'h3f;
    }
    field DrvStrenFSDqN @6 {
       bits 6;
       access rw;
       reset 6'h3f;
    }
  }
  register TxImpedanceCtrl2_b1_p3 @'h30014b {
    field DrvStrenEQHiDqP @0 {
       bits 6;
       access rw;
       reset 6'h0;
    }
    field DrvStrenEQLoDqN @6 {
       bits 6;
       access rw;
       reset 6'h0;
    }
  }
  register TxOdtDrvStren_b1_p3 @'h30014d {
    field ODTStrenP @0 {
       bits 6;
       access rw;
       reset 6'h0;
    }
    field ODTStrenN @6 {
       bits 6;
       access rw;
       reset 6'h0;
    }
  }
  register TxSlewRate_b1_p3 @'h30015f {
    field TxPreP @0 {
       bits 4;
       access rw;
       reset 4'hf;
    }
    field TxPreN @4 {
       bits 4;
       access rw;
       reset 4'hf;
    }
    field TxPreDrvMode @8 {
       bits 3;
       access rw;
       reset 3'h7;
    }
  }
  register RxEnDlyTg0_u1_p3 @'h300180 {
    field RxEnDlyTg0_u1_p3 @0 {
       bits 11;
       access rw;
       reset 11'h100;
    }
  }
  register RxEnDlyTg1_u1_p3 @'h300181 {
    field RxEnDlyTg1_u1_p3 @0 {
       bits 11;
       access rw;
       reset 11'h100;
    }
  }
  register RxEnDlyTg2_u1_p3 @'h300182 {
    field RxEnDlyTg2_u1_p3 @0 {
       bits 11;
       access rw;
       reset 11'h100;
    }
  }
  register RxEnDlyTg3_u1_p3 @'h300183 {
    field RxEnDlyTg3_u1_p3 @0 {
       bits 11;
       access rw;
       reset 11'h100;
    }
  }
  register RxClkDlyTg0_u1_p3 @'h30018c {
    field RxClkDlyTg0_u1_p3 @0 {
       bits 6;
       access rw;
       reset 6'h10;
    }
  }
  register RxClkDlyTg1_u1_p3 @'h30018d {
    field RxClkDlyTg1_u1_p3 @0 {
       bits 6;
       access rw;
       reset 6'h10;
    }
  }
  register RxClkDlyTg2_u1_p3 @'h30018e {
    field RxClkDlyTg2_u1_p3 @0 {
       bits 6;
       access rw;
       reset 6'h10;
    }
  }
  register RxClkDlyTg3_u1_p3 @'h30018f {
    field RxClkDlyTg3_u1_p3 @0 {
       bits 6;
       access rw;
       reset 6'h10;
    }
  }
  register RxClkcDlyTg0_u1_p3 @'h300190 {
    field RxClkcDlyTg0_u1_p3 @0 {
       bits 6;
       access rw;
       reset 6'h10;
    }
  }
  register RxClkcDlyTg1_u1_p3 @'h300191 {
    field RxClkcDlyTg1_u1_p3 @0 {
       bits 6;
       access rw;
       reset 6'h10;
    }
  }
  register RxClkcDlyTg2_u1_p3 @'h300192 {
    field RxClkcDlyTg2_u1_p3 @0 {
       bits 6;
       access rw;
       reset 6'h10;
    }
  }
  register RxClkcDlyTg3_u1_p3 @'h300193 {
    field RxClkcDlyTg3_u1_p3 @0 {
       bits 6;
       access rw;
       reset 6'h10;
    }
  }
  register TxDqDlyTg0_r1_p3 @'h3001c0 {
    field TxDqDlyTg0_r1_p3 @0 {
       bits 9;
       access rw;
       reset 9'h10;
    }
  }
  register TxDqDlyTg1_r1_p3 @'h3001c1 {
    field TxDqDlyTg1_r1_p3 @0 {
       bits 9;
       access rw;
       reset 9'h10;
    }
  }
  register TxDqDlyTg2_r1_p3 @'h3001c2 {
    field TxDqDlyTg2_r1_p3 @0 {
       bits 9;
       access rw;
       reset 9'h10;
    }
  }
  register TxDqDlyTg3_r1_p3 @'h3001c3 {
    field TxDqDlyTg3_r1_p3 @0 {
       bits 9;
       access rw;
       reset 9'h10;
    }
  }
  register TxDqsDlyTg0_u1_p3 @'h3001d0 {
    field TxDqsDlyTg0_u1_p3 @0 {
       bits 10;
       access rw;
       reset 10'h100;
    }
  }
  register TxDqsDlyTg1_u1_p3 @'h3001d1 {
    field TxDqsDlyTg1_u1_p3 @0 {
       bits 10;
       access rw;
       reset 10'h100;
    }
  }
  register TxDqsDlyTg2_u1_p3 @'h3001d2 {
    field TxDqsDlyTg2_u1_p3 @0 {
       bits 10;
       access rw;
       reset 10'h100;
    }
  }
  register TxDqsDlyTg3_u1_p3 @'h3001d3 {
    field TxDqsDlyTg3_u1_p3 @0 {
       bits 10;
       access rw;
       reset 10'h100;
    }
  }
  register TxDqDlyTg0_r2_p3 @'h3002c0 {
    field TxDqDlyTg0_r2_p3 @0 {
       bits 9;
       access rw;
       reset 9'h10;
    }
  }
  register TxDqDlyTg1_r2_p3 @'h3002c1 {
    field TxDqDlyTg1_r2_p3 @0 {
       bits 9;
       access rw;
       reset 9'h10;
    }
  }
  register TxDqDlyTg2_r2_p3 @'h3002c2 {
    field TxDqDlyTg2_r2_p3 @0 {
       bits 9;
       access rw;
       reset 9'h10;
    }
  }
  register TxDqDlyTg3_r2_p3 @'h3002c3 {
    field TxDqDlyTg3_r2_p3 @0 {
       bits 9;
       access rw;
       reset 9'h10;
    }
  }
  register TxDqDlyTg0_r3_p3 @'h3003c0 {
    field TxDqDlyTg0_r3_p3 @0 {
       bits 9;
       access rw;
       reset 9'h10;
    }
  }
  register TxDqDlyTg1_r3_p3 @'h3003c1 {
    field TxDqDlyTg1_r3_p3 @0 {
       bits 9;
       access rw;
       reset 9'h10;
    }
  }
  register TxDqDlyTg2_r3_p3 @'h3003c2 {
    field TxDqDlyTg2_r3_p3 @0 {
       bits 9;
       access rw;
       reset 9'h10;
    }
  }
  register TxDqDlyTg3_r3_p3 @'h3003c3 {
    field TxDqDlyTg3_r3_p3 @0 {
       bits 9;
       access rw;
       reset 9'h10;
    }
  }
  register TxDqDlyTg0_r4_p3 @'h3004c0 {
    field TxDqDlyTg0_r4_p3 @0 {
       bits 9;
       access rw;
       reset 9'h10;
    }
  }
  register TxDqDlyTg1_r4_p3 @'h3004c1 {
    field TxDqDlyTg1_r4_p3 @0 {
       bits 9;
       access rw;
       reset 9'h10;
    }
  }
  register TxDqDlyTg2_r4_p3 @'h3004c2 {
    field TxDqDlyTg2_r4_p3 @0 {
       bits 9;
       access rw;
       reset 9'h10;
    }
  }
  register TxDqDlyTg3_r4_p3 @'h3004c3 {
    field TxDqDlyTg3_r4_p3 @0 {
       bits 9;
       access rw;
       reset 9'h10;
    }
  }
  register TxDqDlyTg0_r5_p3 @'h3005c0 {
    field TxDqDlyTg0_r5_p3 @0 {
       bits 9;
       access rw;
       reset 9'h10;
    }
  }
  register TxDqDlyTg1_r5_p3 @'h3005c1 {
    field TxDqDlyTg1_r5_p3 @0 {
       bits 9;
       access rw;
       reset 9'h10;
    }
  }
  register TxDqDlyTg2_r5_p3 @'h3005c2 {
    field TxDqDlyTg2_r5_p3 @0 {
       bits 9;
       access rw;
       reset 9'h10;
    }
  }
  register TxDqDlyTg3_r5_p3 @'h3005c3 {
    field TxDqDlyTg3_r5_p3 @0 {
       bits 9;
       access rw;
       reset 9'h10;
    }
  }
  register TxDqDlyTg0_r6_p3 @'h3006c0 {
    field TxDqDlyTg0_r6_p3 @0 {
       bits 9;
       access rw;
       reset 9'h10;
    }
  }
  register TxDqDlyTg1_r6_p3 @'h3006c1 {
    field TxDqDlyTg1_r6_p3 @0 {
       bits 9;
       access rw;
       reset 9'h10;
    }
  }
  register TxDqDlyTg2_r6_p3 @'h3006c2 {
    field TxDqDlyTg2_r6_p3 @0 {
       bits 9;
       access rw;
       reset 9'h10;
    }
  }
  register TxDqDlyTg3_r6_p3 @'h3006c3 {
    field TxDqDlyTg3_r6_p3 @0 {
       bits 9;
       access rw;
       reset 9'h10;
    }
  }
  register TxDqDlyTg0_r7_p3 @'h3007c0 {
    field TxDqDlyTg0_r7_p3 @0 {
       bits 9;
       access rw;
       reset 9'h10;
    }
  }
  register TxDqDlyTg1_r7_p3 @'h3007c1 {
    field TxDqDlyTg1_r7_p3 @0 {
       bits 9;
       access rw;
       reset 9'h10;
    }
  }
  register TxDqDlyTg2_r7_p3 @'h3007c2 {
    field TxDqDlyTg2_r7_p3 @0 {
       bits 9;
       access rw;
       reset 9'h10;
    }
  }
  register TxDqDlyTg3_r7_p3 @'h3007c3 {
    field TxDqDlyTg3_r7_p3 @0 {
       bits 9;
       access rw;
       reset 9'h10;
    }
  }
  register TxDqDlyTg0_r8_p3 @'h3008c0 {
    field TxDqDlyTg0_r8_p3 @0 {
       bits 9;
       access rw;
       reset 9'h10;
    }
  }
  register TxDqDlyTg1_r8_p3 @'h3008c1 {
    field TxDqDlyTg1_r8_p3 @0 {
       bits 9;
       access rw;
       reset 9'h10;
    }
  }
  register TxDqDlyTg2_r8_p3 @'h3008c2 {
    field TxDqDlyTg2_r8_p3 @0 {
       bits 9;
       access rw;
       reset 9'h10;
    }
  }
  register TxDqDlyTg3_r8_p3 @'h3008c3 {
    field TxDqDlyTg3_r8_p3 @0 {
       bits 9;
       access rw;
       reset 9'h10;
    }
  }
}
block dwc_ddrphy_top_DWC_DDRPHYA_DRTUB0 {
  endian little;
  bytes 2;
  register DctShadowRegs @'h4 {
    field RFU_DctShadowRegs @0 {
       bits 1;
       access ro;
       reset 1'h0;
    }
  }
  register DctWriteOnlyShadow @'h30 {
    field DctWriteOnlyShadow @0 {
       bits 16;
       access ro;
       reset 16'h0;
    }
  }
  register UctWriteOnly @'h32 {
    field UctWriteOnly @0 {
       bits 16;
       access rw;
       reset 16'h0;
    }
  }
  register UctWriteProt @'h33 {
    field UctWriteProt @0 {
       bits 1;
       access rw;
       reset 1'h1;
    }
  }
  register UctDatWriteOnly @'h34 {
    field UctDatWriteOnly @0 {
       bits 16;
       access rw;
       reset 16'h0;
    }
  }
  register UctDatWriteProt @'h35 {
    field UctDatWriteProt @0 {
       bits 1;
       access rw;
       reset 1'h1;
    }
  }
  register UctlErr @'h36 {
    field UctlErr @0 {
       bits 1;
       access rw;
       reset 1'h0;
    }
  }
  register UcclkHclkEnables @'h80 {
    field UcclkEn @0 {
       bits 1;
       access rw;
       reset 1'h1;
    }
    field HclkEn @1 {
       bits 1;
       access rw;
       reset 1'h1;
    }
  }
  register CurPstate0b @'h81 {
    field CurPstate0b @0 {
       bits 4;
       access rw;
       reset 4'h0;
    }
  }
  register ClrWakeupSticky @'h95 {
    field ClrWakeupSticky @0 {
       bits 4;
       access rw;
       reset 4'h0;
    }
  }
  register WakeupMask @'h96 {
    field WakeupMask @0 {
       bits 4;
       access rw;
       reset 4'h0;
    }
  }
  register CUSTPUBREV @'hed {
    field CUSTPUBREV @0 {
       bits 6;
       access ro;
       reset 6'h0;
    }
  }
  register PUBREV @'hee {
    field PUBMNR @0 {
       bits 4;
       access ro;
       reset 4'h0;
    }
    field PUBMDR @4 {
       bits 4;
       access ro;
       reset 4'h1;
    }
    field PUBMJR @8 {
       bits 8;
       access ro;
       reset 8'h24;
    }
  }
}
block dwc_ddrphy_top_DWC_DDRPHYA_INITENG0 {
  endian little;
  bytes 2;
  register PreSequenceReg0b0s0 @'h0 {
    field PreSequenceReg0b0s0 @0 {
       bits 16;
       access rw;
       reset 16'h0;
    }
  }
  register PreSequenceReg0b0s1 @'h1 {
    field PreSequenceReg0b0s1 @0 {
       bits 16;
       access rw;
       reset 16'h0;
    }
  }
  register PreSequenceReg0b0s2 @'h2 {
    field PreSequenceReg0b0s2 @0 {
       bits 9;
       access rw;
       reset 9'h0;
    }
  }
  register PreSequenceReg0b1s0 @'h3 {
    field PreSequenceReg0b1s0 @0 {
       bits 16;
       access rw;
       reset 16'h0;
    }
  }
  register PreSequenceReg0b1s1 @'h4 {
    field PreSequenceReg0b1s1 @0 {
       bits 16;
       access rw;
       reset 16'h0;
    }
  }
  register PreSequenceReg0b1s2 @'h5 {
    field PreSequenceReg0b1s2 @0 {
       bits 9;
       access rw;
       reset 9'h0;
    }
  }
  register PostSequenceReg0b0s0 @'h6 {
    field PostSequenceReg0b0s0 @0 {
       bits 16;
       access rw;
       reset 16'h0;
    }
  }
  register PostSequenceReg0b0s1 @'h7 {
    field PostSequenceReg0b0s1 @0 {
       bits 16;
       access rw;
       reset 16'h0;
    }
  }
  register PostSequenceReg0b0s2 @'h8 {
    field PostSequenceReg0b0s2 @0 {
       bits 9;
       access rw;
       reset 9'h0;
    }
  }
  register PostSequenceReg0b1s0 @'h9 {
    field PostSequenceReg0b1s0 @0 {
       bits 16;
       access rw;
       reset 16'h0;
    }
  }
  register PostSequenceReg0b1s1 @'ha {
    field PostSequenceReg0b1s1 @0 {
       bits 16;
       access rw;
       reset 16'h0;
    }
  }
  register PostSequenceReg0b1s2 @'hb {
    field PostSequenceReg0b1s2 @0 {
       bits 9;
       access rw;
       reset 9'h0;
    }
  }
  register Seq0BDisableFlag0 @'hc {
    field Seq0BDisableFlag0 @0 {
       bits 16;
       access rw;
       reset 16'h0;
    }
  }
  register Seq0BDisableFlag1 @'hd {
    field Seq0BDisableFlag1 @0 {
       bits 16;
       access rw;
       reset 16'h0;
    }
  }
  register Seq0BDisableFlag2 @'he {
    field Seq0BDisableFlag2 @0 {
       bits 16;
       access rw;
       reset 16'h0;
    }
  }
  register Seq0BDisableFlag3 @'hf {
    field Seq0BDisableFlag3 @0 {
       bits 16;
       access rw;
       reset 16'h0;
    }
  }
  register Seq0BDisableFlag4 @'h10 {
    field Seq0BDisableFlag4 @0 {
       bits 16;
       access rw;
       reset 16'h0;
    }
  }
  register Seq0BDisableFlag5 @'h11 {
    field Seq0BDisableFlag5 @0 {
       bits 16;
       access rw;
       reset 16'h0;
    }
  }
  register Seq0BDisableFlag6 @'h12 {
    field Seq0BDisableFlag6 @0 {
       bits 16;
       access rw;
       reset 16'h0;
    }
  }
  register Seq0BDisableFlag7 @'h13 {
    field Seq0BDisableFlag7 @0 {
       bits 16;
       access rw;
       reset 16'h0;
    }
  }
  register StartVector0b0 @'h17 {
    field RFU_StartVector0b0 @0 {
       bits 7;
       access rw;
       reset 7'h0;
    }
  }
  register StartVector0b1 @'h18 {
    field RFU_StartVector0b1 @0 {
       bits 7;
       access rw;
       reset 7'h0;
    }
  }
  register StartVector0b2 @'h19 {
    field RFU_StartVector0b2 @0 {
       bits 7;
       access rw;
       reset 7'h0;
    }
  }
  register StartVector0b3 @'h1a {
    field RFU_StartVector0b3 @0 {
       bits 7;
       access rw;
       reset 7'h0;
    }
  }
  register StartVector0b4 @'h1b {
    field RFU_StartVector0b4 @0 {
       bits 7;
       access rw;
       reset 7'h0;
    }
  }
  register StartVector0b5 @'h1c {
    field RFU_StartVector0b5 @0 {
       bits 7;
       access rw;
       reset 7'h0;
    }
  }
  register StartVector0b6 @'h1d {
    field RFU_StartVector0b6 @0 {
       bits 7;
       access rw;
       reset 7'h0;
    }
  }
  register StartVector0b7 @'h1e {
    field RFU_StartVector0b7 @0 {
       bits 7;
       access rw;
       reset 7'h0;
    }
  }
  register StartVector0b8 @'h1f {
    field RFU_StartVector0b8 @0 {
       bits 7;
       access rw;
       reset 7'h0;
    }
  }
  register StartVector0b9 @'h20 {
    field RFU_StartVector0b9 @0 {
       bits 7;
       access rw;
       reset 7'h0;
    }
  }
  register StartVector0b10 @'h21 {
    field RFU_StartVector0b10 @0 {
       bits 7;
       access rw;
       reset 7'h0;
    }
  }
  register StartVector0b11 @'h22 {
    field RFU_StartVector0b11 @0 {
       bits 7;
       access rw;
       reset 7'h0;
    }
  }
  register StartVector0b12 @'h23 {
    field RFU_StartVector0b12 @0 {
       bits 7;
       access rw;
       reset 7'h0;
    }
  }
  register StartVector0b13 @'h24 {
    field RFU_StartVector0b13 @0 {
       bits 7;
       access rw;
       reset 7'h0;
    }
  }
  register StartVector0b14 @'h25 {
    field RFU_StartVector0b14 @0 {
       bits 7;
       access rw;
       reset 7'h0;
    }
  }
  register StartVector0b15 @'h26 {
    field RFU_StartVector0b15 @0 {
       bits 7;
       access rw;
       reset 7'h0;
    }
  }
  register Seq0bWaitCondSel @'h27 {
    field Seq0bWaitCondSel @0 {
       bits 3;
       access rw;
       reset 3'h0;
    }
  }
  register PhyInLP3 @'h28 {
    field PhyInLP3 @0 {
       bits 1;
       access rw;
       reset 1'h1;
    }
  }
  register SequenceReg0b0s0 @'h29 {
    field SequenceReg0b0s0 @0 {
       bits 16;
       access rw;
       reset 16'h0;
    }
  }
  register SequenceReg0b0s1 @'h2a {
    field SequenceReg0b0s1 @0 {
       bits 16;
       access rw;
       reset 16'h0;
    }
  }
  register SequenceReg0b0s2 @'h2b {
    field SequenceReg0b0s2 @0 {
       bits 9;
       access rw;
       reset 9'h0;
    }
  }
  register SequenceReg0b1s0 @'h2c {
    field SequenceReg0b1s0 @0 {
       bits 16;
       access rw;
       reset 16'h0;
    }
  }
  register SequenceReg0b1s1 @'h2d {
    field SequenceReg0b1s1 @0 {
       bits 16;
       access rw;
       reset 16'h0;
    }
  }
  register SequenceReg0b1s2 @'h2e {
    field SequenceReg0b1s2 @0 {
       bits 9;
       access rw;
       reset 9'h0;
    }
  }
  register SequenceReg0b2s0 @'h2f {
    field SequenceReg0b2s0 @0 {
       bits 16;
       access rw;
       reset 16'h0;
    }
  }
  register SequenceReg0b2s1 @'h30 {
    field SequenceReg0b2s1 @0 {
       bits 16;
       access rw;
       reset 16'h0;
    }
  }
  register SequenceReg0b2s2 @'h31 {
    field SequenceReg0b2s2 @0 {
       bits 9;
       access rw;
       reset 9'h0;
    }
  }
  register SequenceReg0b3s0 @'h32 {
    field SequenceReg0b3s0 @0 {
       bits 16;
       access rw;
       reset 16'h0;
    }
  }
  register SequenceReg0b3s1 @'h33 {
    field SequenceReg0b3s1 @0 {
       bits 16;
       access rw;
       reset 16'h0;
    }
  }
  register SequenceReg0b3s2 @'h34 {
    field SequenceReg0b3s2 @0 {
       bits 9;
       access rw;
       reset 9'h0;
    }
  }
  register SequenceReg0b4s0 @'h35 {
    field SequenceReg0b4s0 @0 {
       bits 16;
       access rw;
       reset 16'h0;
    }
  }
  register SequenceReg0b4s1 @'h36 {
    field SequenceReg0b4s1 @0 {
       bits 16;
       access rw;
       reset 16'h0;
    }
  }
  register SequenceReg0b4s2 @'h37 {
    field SequenceReg0b4s2 @0 {
       bits 9;
       access rw;
       reset 9'h0;
    }
  }
  register SequenceReg0b5s0 @'h38 {
    field SequenceReg0b5s0 @0 {
       bits 16;
       access rw;
       reset 16'h0;
    }
  }
  register SequenceReg0b5s1 @'h39 {
    field SequenceReg0b5s1 @0 {
       bits 16;
       access rw;
       reset 16'h0;
    }
  }
  register SequenceReg0b5s2 @'h3a {
    field SequenceReg0b5s2 @0 {
       bits 9;
       access rw;
       reset 9'h0;
    }
  }
  register SequenceReg0b6s0 @'h3b {
    field SequenceReg0b6s0 @0 {
       bits 16;
       access rw;
       reset 16'h0;
    }
  }
  register SequenceReg0b6s1 @'h3c {
    field SequenceReg0b6s1 @0 {
       bits 16;
       access rw;
       reset 16'h0;
    }
  }
  register SequenceReg0b6s2 @'h3d {
    field SequenceReg0b6s2 @0 {
       bits 9;
       access rw;
       reset 9'h0;
    }
  }
  register SequenceReg0b7s0 @'h3e {
    field SequenceReg0b7s0 @0 {
       bits 16;
       access rw;
       reset 16'h0;
    }
  }
  register SequenceReg0b7s1 @'h3f {
    field SequenceReg0b7s1 @0 {
       bits 16;
       access rw;
       reset 16'h0;
    }
  }
  register SequenceReg0b7s2 @'h40 {
    field SequenceReg0b7s2 @0 {
       bits 9;
       access rw;
       reset 9'h0;
    }
  }
  register SequenceReg0b8s0 @'h41 {
    field SequenceReg0b8s0 @0 {
       bits 16;
       access rw;
       reset 16'h0;
    }
  }
  register SequenceReg0b8s1 @'h42 {
    field SequenceReg0b8s1 @0 {
       bits 16;
       access rw;
       reset 16'h0;
    }
  }
  register SequenceReg0b8s2 @'h43 {
    field SequenceReg0b8s2 @0 {
       bits 9;
       access rw;
       reset 9'h0;
    }
  }
  register SequenceReg0b9s0 @'h44 {
    field SequenceReg0b9s0 @0 {
       bits 16;
       access rw;
       reset 16'h0;
    }
  }
  register SequenceReg0b9s1 @'h45 {
    field SequenceReg0b9s1 @0 {
       bits 16;
       access rw;
       reset 16'h0;
    }
  }
  register SequenceReg0b9s2 @'h46 {
    field SequenceReg0b9s2 @0 {
       bits 9;
       access rw;
       reset 9'h0;
    }
  }
  register SequenceReg0b10s0 @'h47 {
    field SequenceReg0b10s0 @0 {
       bits 16;
       access rw;
       reset 16'h0;
    }
  }
  register SequenceReg0b10s1 @'h48 {
    field SequenceReg0b10s1 @0 {
       bits 16;
       access rw;
       reset 16'h0;
    }
  }
  register SequenceReg0b10s2 @'h49 {
    field SequenceReg0b10s2 @0 {
       bits 9;
       access rw;
       reset 9'h0;
    }
  }
  register SequenceReg0b11s0 @'h4a {
    field SequenceReg0b11s0 @0 {
       bits 16;
       access rw;
       reset 16'h0;
    }
  }
  register SequenceReg0b11s1 @'h4b {
    field SequenceReg0b11s1 @0 {
       bits 16;
       access rw;
       reset 16'h0;
    }
  }
  register SequenceReg0b11s2 @'h4c {
    field SequenceReg0b11s2 @0 {
       bits 9;
       access rw;
       reset 9'h0;
    }
  }
  register SequenceReg0b12s0 @'h4d {
    field SequenceReg0b12s0 @0 {
       bits 16;
       access rw;
       reset 16'h0;
    }
  }
  register SequenceReg0b12s1 @'h4e {
    field SequenceReg0b12s1 @0 {
       bits 16;
       access rw;
       reset 16'h0;
    }
  }
  register SequenceReg0b12s2 @'h4f {
    field SequenceReg0b12s2 @0 {
       bits 9;
       access rw;
       reset 9'h0;
    }
  }
  register SequenceReg0b13s0 @'h50 {
    field SequenceReg0b13s0 @0 {
       bits 16;
       access rw;
       reset 16'h0;
    }
  }
  register SequenceReg0b13s1 @'h51 {
    field SequenceReg0b13s1 @0 {
       bits 16;
       access rw;
       reset 16'h0;
    }
  }
  register SequenceReg0b13s2 @'h52 {
    field SequenceReg0b13s2 @0 {
       bits 9;
       access rw;
       reset 9'h0;
    }
  }
  register SequenceReg0b14s0 @'h53 {
    field SequenceReg0b14s0 @0 {
       bits 16;
       access rw;
       reset 16'h0;
    }
  }
  register SequenceReg0b14s1 @'h54 {
    field SequenceReg0b14s1 @0 {
       bits 16;
       access rw;
       reset 16'h0;
    }
  }
  register SequenceReg0b14s2 @'h55 {
    field SequenceReg0b14s2 @0 {
       bits 9;
       access rw;
       reset 9'h0;
    }
  }
  register SequenceReg0b15s0 @'h56 {
    field SequenceReg0b15s0 @0 {
       bits 16;
       access rw;
       reset 16'h0;
    }
  }
  register SequenceReg0b15s1 @'h57 {
    field SequenceReg0b15s1 @0 {
       bits 16;
       access rw;
       reset 16'h0;
    }
  }
  register SequenceReg0b15s2 @'h58 {
    field SequenceReg0b15s2 @0 {
       bits 9;
       access rw;
       reset 9'h0;
    }
  }
  register SequenceReg0b16s0 @'h59 {
    field SequenceReg0b16s0 @0 {
       bits 16;
       access rw;
       reset 16'h0;
    }
  }
  register SequenceReg0b16s1 @'h5a {
    field SequenceReg0b16s1 @0 {
       bits 16;
       access rw;
       reset 16'h0;
    }
  }
  register SequenceReg0b16s2 @'h5b {
    field SequenceReg0b16s2 @0 {
       bits 9;
       access rw;
       reset 9'h0;
    }
  }
  register SequenceReg0b17s0 @'h5c {
    field SequenceReg0b17s0 @0 {
       bits 16;
       access rw;
       reset 16'h0;
    }
  }
  register SequenceReg0b17s1 @'h5d {
    field SequenceReg0b17s1 @0 {
       bits 16;
       access rw;
       reset 16'h0;
    }
  }
  register SequenceReg0b17s2 @'h5e {
    field SequenceReg0b17s2 @0 {
       bits 9;
       access rw;
       reset 9'h0;
    }
  }
  register SequenceReg0b18s0 @'h5f {
    field SequenceReg0b18s0 @0 {
       bits 16;
       access rw;
       reset 16'h0;
    }
  }
  register SequenceReg0b18s1 @'h60 {
    field SequenceReg0b18s1 @0 {
       bits 16;
       access rw;
       reset 16'h0;
    }
  }
  register SequenceReg0b18s2 @'h61 {
    field SequenceReg0b18s2 @0 {
       bits 9;
       access rw;
       reset 9'h0;
    }
  }
  register SequenceReg0b19s0 @'h62 {
    field SequenceReg0b19s0 @0 {
       bits 16;
       access rw;
       reset 16'h0;
    }
  }
  register SequenceReg0b19s1 @'h63 {
    field SequenceReg0b19s1 @0 {
       bits 16;
       access rw;
       reset 16'h0;
    }
  }
  register SequenceReg0b19s2 @'h64 {
    field SequenceReg0b19s2 @0 {
       bits 9;
       access rw;
       reset 9'h0;
    }
  }
  register SequenceReg0b20s0 @'h65 {
    field SequenceReg0b20s0 @0 {
       bits 16;
       access rw;
       reset 16'h0;
    }
  }
  register SequenceReg0b20s1 @'h66 {
    field SequenceReg0b20s1 @0 {
       bits 16;
       access rw;
       reset 16'h0;
    }
  }
  register SequenceReg0b20s2 @'h67 {
    field SequenceReg0b20s2 @0 {
       bits 9;
       access rw;
       reset 9'h0;
    }
  }
  register SequenceReg0b21s0 @'h68 {
    field SequenceReg0b21s0 @0 {
       bits 16;
       access rw;
       reset 16'h0;
    }
  }
  register SequenceReg0b21s1 @'h69 {
    field SequenceReg0b21s1 @0 {
       bits 16;
       access rw;
       reset 16'h0;
    }
  }
  register SequenceReg0b21s2 @'h6a {
    field SequenceReg0b21s2 @0 {
       bits 9;
       access rw;
       reset 9'h0;
    }
  }
  register SequenceReg0b22s0 @'h6b {
    field SequenceReg0b22s0 @0 {
       bits 16;
       access rw;
       reset 16'h0;
    }
  }
  register SequenceReg0b22s1 @'h6c {
    field SequenceReg0b22s1 @0 {
       bits 16;
       access rw;
       reset 16'h0;
    }
  }
  register SequenceReg0b22s2 @'h6d {
    field SequenceReg0b22s2 @0 {
       bits 9;
       access rw;
       reset 9'h0;
    }
  }
  register SequenceReg0b23s0 @'h6e {
    field SequenceReg0b23s0 @0 {
       bits 16;
       access rw;
       reset 16'h0;
    }
  }
  register SequenceReg0b23s1 @'h6f {
    field SequenceReg0b23s1 @0 {
       bits 16;
       access rw;
       reset 16'h0;
    }
  }
  register SequenceReg0b23s2 @'h70 {
    field SequenceReg0b23s2 @0 {
       bits 9;
       access rw;
       reset 9'h0;
    }
  }
  register SequenceReg0b24s0 @'h71 {
    field SequenceReg0b24s0 @0 {
       bits 16;
       access rw;
       reset 16'h0;
    }
  }
  register SequenceReg0b24s1 @'h72 {
    field SequenceReg0b24s1 @0 {
       bits 16;
       access rw;
       reset 16'h0;
    }
  }
  register SequenceReg0b24s2 @'h73 {
    field SequenceReg0b24s2 @0 {
       bits 9;
       access rw;
       reset 9'h0;
    }
  }
  register SequenceReg0b25s0 @'h74 {
    field SequenceReg0b25s0 @0 {
       bits 16;
       access rw;
       reset 16'h0;
    }
  }
  register SequenceReg0b25s1 @'h75 {
    field SequenceReg0b25s1 @0 {
       bits 16;
       access rw;
       reset 16'h0;
    }
  }
  register SequenceReg0b25s2 @'h76 {
    field SequenceReg0b25s2 @0 {
       bits 9;
       access rw;
       reset 9'h0;
    }
  }
  register SequenceReg0b26s0 @'h77 {
    field SequenceReg0b26s0 @0 {
       bits 16;
       access rw;
       reset 16'h0;
    }
  }
  register SequenceReg0b26s1 @'h78 {
    field SequenceReg0b26s1 @0 {
       bits 16;
       access rw;
       reset 16'h0;
    }
  }
  register SequenceReg0b26s2 @'h79 {
    field SequenceReg0b26s2 @0 {
       bits 9;
       access rw;
       reset 9'h0;
    }
  }
  register SequenceReg0b27s0 @'h7a {
    field SequenceReg0b27s0 @0 {
       bits 16;
       access rw;
       reset 16'h0;
    }
  }
  register SequenceReg0b27s1 @'h7b {
    field SequenceReg0b27s1 @0 {
       bits 16;
       access rw;
       reset 16'h0;
    }
  }
  register SequenceReg0b27s2 @'h7c {
    field SequenceReg0b27s2 @0 {
       bits 9;
       access rw;
       reset 9'h0;
    }
  }
  register SequenceReg0b28s0 @'h7d {
    field SequenceReg0b28s0 @0 {
       bits 16;
       access rw;
       reset 16'h0;
    }
  }
  register SequenceReg0b28s1 @'h7e {
    field SequenceReg0b28s1 @0 {
       bits 16;
       access rw;
       reset 16'h0;
    }
  }
  register SequenceReg0b28s2 @'h7f {
    field SequenceReg0b28s2 @0 {
       bits 9;
       access rw;
       reset 9'h0;
    }
  }
  register SequenceReg0b29s0 @'h80 {
    field SequenceReg0b29s0 @0 {
       bits 16;
       access rw;
       reset 16'h0;
    }
  }
  register SequenceReg0b29s1 @'h81 {
    field SequenceReg0b29s1 @0 {
       bits 16;
       access rw;
       reset 16'h0;
    }
  }
  register SequenceReg0b29s2 @'h82 {
    field SequenceReg0b29s2 @0 {
       bits 9;
       access rw;
       reset 9'h0;
    }
  }
  register SequenceReg0b30s0 @'h83 {
    field SequenceReg0b30s0 @0 {
       bits 16;
       access rw;
       reset 16'h0;
    }
  }
  register SequenceReg0b30s1 @'h84 {
    field SequenceReg0b30s1 @0 {
       bits 16;
       access rw;
       reset 16'h0;
    }
  }
  register SequenceReg0b30s2 @'h85 {
    field SequenceReg0b30s2 @0 {
       bits 9;
       access rw;
       reset 9'h0;
    }
  }
  register SequenceReg0b31s0 @'h86 {
    field SequenceReg0b31s0 @0 {
       bits 16;
       access rw;
       reset 16'h0;
    }
  }
  register SequenceReg0b31s1 @'h87 {
    field SequenceReg0b31s1 @0 {
       bits 16;
       access rw;
       reset 16'h0;
    }
  }
  register SequenceReg0b31s2 @'h88 {
    field SequenceReg0b31s2 @0 {
       bits 9;
       access rw;
       reset 9'h0;
    }
  }
  register SequenceReg0b32s0 @'h89 {
    field SequenceReg0b32s0 @0 {
       bits 16;
       access rw;
       reset 16'h0;
    }
  }
  register SequenceReg0b32s1 @'h8a {
    field SequenceReg0b32s1 @0 {
       bits 16;
       access rw;
       reset 16'h0;
    }
  }
  register SequenceReg0b32s2 @'h8b {
    field SequenceReg0b32s2 @0 {
       bits 9;
       access rw;
       reset 9'h0;
    }
  }
  register SequenceReg0b33s0 @'h8c {
    field SequenceReg0b33s0 @0 {
       bits 16;
       access rw;
       reset 16'h0;
    }
  }
  register SequenceReg0b33s1 @'h8d {
    field SequenceReg0b33s1 @0 {
       bits 16;
       access rw;
       reset 16'h0;
    }
  }
  register SequenceReg0b33s2 @'h8e {
    field SequenceReg0b33s2 @0 {
       bits 9;
       access rw;
       reset 9'h0;
    }
  }
  register SequenceReg0b34s0 @'h8f {
    field SequenceReg0b34s0 @0 {
       bits 16;
       access rw;
       reset 16'h0;
    }
  }
  register SequenceReg0b34s1 @'h90 {
    field SequenceReg0b34s1 @0 {
       bits 16;
       access rw;
       reset 16'h0;
    }
  }
  register SequenceReg0b34s2 @'h91 {
    field SequenceReg0b34s2 @0 {
       bits 9;
       access rw;
       reset 9'h0;
    }
  }
  register SequenceReg0b35s0 @'h92 {
    field SequenceReg0b35s0 @0 {
       bits 16;
       access rw;
       reset 16'h0;
    }
  }
  register SequenceReg0b35s1 @'h93 {
    field SequenceReg0b35s1 @0 {
       bits 16;
       access rw;
       reset 16'h0;
    }
  }
  register SequenceReg0b35s2 @'h94 {
    field SequenceReg0b35s2 @0 {
       bits 9;
       access rw;
       reset 9'h0;
    }
  }
  register SequenceReg0b36s0 @'h95 {
    field SequenceReg0b36s0 @0 {
       bits 16;
       access rw;
       reset 16'h0;
    }
  }
  register SequenceReg0b36s1 @'h96 {
    field SequenceReg0b36s1 @0 {
       bits 16;
       access rw;
       reset 16'h0;
    }
  }
  register SequenceReg0b36s2 @'h97 {
    field SequenceReg0b36s2 @0 {
       bits 9;
       access rw;
       reset 9'h0;
    }
  }
  register SequenceReg0b37s0 @'h98 {
    field SequenceReg0b37s0 @0 {
       bits 16;
       access rw;
       reset 16'h0;
    }
  }
  register SequenceReg0b37s1 @'h99 {
    field SequenceReg0b37s1 @0 {
       bits 16;
       access rw;
       reset 16'h0;
    }
  }
  register SequenceReg0b37s2 @'h9a {
    field SequenceReg0b37s2 @0 {
       bits 9;
       access rw;
       reset 9'h0;
    }
  }
  register SequenceReg0b38s0 @'h9b {
    field SequenceReg0b38s0 @0 {
       bits 16;
       access rw;
       reset 16'h0;
    }
  }
  register SequenceReg0b38s1 @'h9c {
    field SequenceReg0b38s1 @0 {
       bits 16;
       access rw;
       reset 16'h0;
    }
  }
  register SequenceReg0b38s2 @'h9d {
    field SequenceReg0b38s2 @0 {
       bits 9;
       access rw;
       reset 9'h0;
    }
  }
  register SequenceReg0b39s0 @'h9e {
    field SequenceReg0b39s0 @0 {
       bits 16;
       access rw;
       reset 16'h0;
    }
  }
  register SequenceReg0b39s1 @'h9f {
    field SequenceReg0b39s1 @0 {
       bits 16;
       access rw;
       reset 16'h0;
    }
  }
  register SequenceReg0b39s2 @'ha0 {
    field SequenceReg0b39s2 @0 {
       bits 9;
       access rw;
       reset 9'h0;
    }
  }
  register SequenceReg0b40s0 @'ha1 {
    field SequenceReg0b40s0 @0 {
       bits 16;
       access rw;
       reset 16'h0;
    }
  }
  register SequenceReg0b40s1 @'ha2 {
    field SequenceReg0b40s1 @0 {
       bits 16;
       access rw;
       reset 16'h0;
    }
  }
  register SequenceReg0b40s2 @'ha3 {
    field SequenceReg0b40s2 @0 {
       bits 9;
       access rw;
       reset 9'h0;
    }
  }
  register SequenceReg0b41s0 @'ha4 {
    field SequenceReg0b41s0 @0 {
       bits 16;
       access rw;
       reset 16'h0;
    }
  }
  register SequenceReg0b41s1 @'ha5 {
    field SequenceReg0b41s1 @0 {
       bits 16;
       access rw;
       reset 16'h0;
    }
  }
  register SequenceReg0b41s2 @'ha6 {
    field SequenceReg0b41s2 @0 {
       bits 9;
       access rw;
       reset 9'h0;
    }
  }
  register SequenceReg0b42s0 @'ha7 {
    field SequenceReg0b42s0 @0 {
       bits 16;
       access rw;
       reset 16'h0;
    }
  }
  register SequenceReg0b42s1 @'ha8 {
    field SequenceReg0b42s1 @0 {
       bits 16;
       access rw;
       reset 16'h0;
    }
  }
  register SequenceReg0b42s2 @'ha9 {
    field SequenceReg0b42s2 @0 {
       bits 9;
       access rw;
       reset 9'h0;
    }
  }
  register SequenceReg0b43s0 @'haa {
    field SequenceReg0b43s0 @0 {
       bits 16;
       access rw;
       reset 16'h0;
    }
  }
  register SequenceReg0b43s1 @'hab {
    field SequenceReg0b43s1 @0 {
       bits 16;
       access rw;
       reset 16'h0;
    }
  }
  register SequenceReg0b43s2 @'hac {
    field SequenceReg0b43s2 @0 {
       bits 9;
       access rw;
       reset 9'h0;
    }
  }
  register SequenceReg0b44s0 @'had {
    field SequenceReg0b44s0 @0 {
       bits 16;
       access rw;
       reset 16'h0;
    }
  }
  register SequenceReg0b44s1 @'hae {
    field SequenceReg0b44s1 @0 {
       bits 16;
       access rw;
       reset 16'h0;
    }
  }
  register SequenceReg0b44s2 @'haf {
    field SequenceReg0b44s2 @0 {
       bits 9;
       access rw;
       reset 9'h0;
    }
  }
  register SequenceReg0b45s0 @'hb0 {
    field SequenceReg0b45s0 @0 {
       bits 16;
       access rw;
       reset 16'h0;
    }
  }
  register SequenceReg0b45s1 @'hb1 {
    field SequenceReg0b45s1 @0 {
       bits 16;
       access rw;
       reset 16'h0;
    }
  }
  register SequenceReg0b45s2 @'hb2 {
    field SequenceReg0b45s2 @0 {
       bits 9;
       access rw;
       reset 9'h0;
    }
  }
  register SequenceReg0b46s0 @'hb3 {
    field SequenceReg0b46s0 @0 {
       bits 16;
       access rw;
       reset 16'h0;
    }
  }
  register SequenceReg0b46s1 @'hb4 {
    field SequenceReg0b46s1 @0 {
       bits 16;
       access rw;
       reset 16'h0;
    }
  }
  register SequenceReg0b46s2 @'hb5 {
    field SequenceReg0b46s2 @0 {
       bits 9;
       access rw;
       reset 9'h0;
    }
  }
  register SequenceReg0b47s0 @'hb6 {
    field SequenceReg0b47s0 @0 {
       bits 16;
       access rw;
       reset 16'h0;
    }
  }
  register SequenceReg0b47s1 @'hb7 {
    field SequenceReg0b47s1 @0 {
       bits 16;
       access rw;
       reset 16'h0;
    }
  }
  register SequenceReg0b47s2 @'hb8 {
    field SequenceReg0b47s2 @0 {
       bits 9;
       access rw;
       reset 9'h0;
    }
  }
  register SequenceReg0b48s0 @'hb9 {
    field SequenceReg0b48s0 @0 {
       bits 16;
       access rw;
       reset 16'h0;
    }
  }
  register SequenceReg0b48s1 @'hba {
    field SequenceReg0b48s1 @0 {
       bits 16;
       access rw;
       reset 16'h0;
    }
  }
  register SequenceReg0b48s2 @'hbb {
    field SequenceReg0b48s2 @0 {
       bits 9;
       access rw;
       reset 9'h0;
    }
  }
  register SequenceReg0b49s0 @'hbc {
    field SequenceReg0b49s0 @0 {
       bits 16;
       access rw;
       reset 16'h0;
    }
  }
  register SequenceReg0b49s1 @'hbd {
    field SequenceReg0b49s1 @0 {
       bits 16;
       access rw;
       reset 16'h0;
    }
  }
  register SequenceReg0b49s2 @'hbe {
    field SequenceReg0b49s2 @0 {
       bits 9;
       access rw;
       reset 9'h0;
    }
  }
  register SequenceReg0b50s0 @'hbf {
    field SequenceReg0b50s0 @0 {
       bits 16;
       access rw;
       reset 16'h0;
    }
  }
  register SequenceReg0b50s1 @'hc0 {
    field SequenceReg0b50s1 @0 {
       bits 16;
       access rw;
       reset 16'h0;
    }
  }
  register SequenceReg0b50s2 @'hc1 {
    field SequenceReg0b50s2 @0 {
       bits 9;
       access rw;
       reset 9'h0;
    }
  }
  register SequenceReg0b51s0 @'hc2 {
    field SequenceReg0b51s0 @0 {
       bits 16;
       access rw;
       reset 16'h0;
    }
  }
  register SequenceReg0b51s1 @'hc3 {
    field SequenceReg0b51s1 @0 {
       bits 16;
       access rw;
       reset 16'h0;
    }
  }
  register SequenceReg0b51s2 @'hc4 {
    field SequenceReg0b51s2 @0 {
       bits 9;
       access rw;
       reset 9'h0;
    }
  }
  register SequenceReg0b52s0 @'hc5 {
    field SequenceReg0b52s0 @0 {
       bits 16;
       access rw;
       reset 16'h0;
    }
  }
  register SequenceReg0b52s1 @'hc6 {
    field SequenceReg0b52s1 @0 {
       bits 16;
       access rw;
       reset 16'h0;
    }
  }
  register SequenceReg0b52s2 @'hc7 {
    field SequenceReg0b52s2 @0 {
       bits 9;
       access rw;
       reset 9'h0;
    }
  }
  register SequenceReg0b53s0 @'hc8 {
    field SequenceReg0b53s0 @0 {
       bits 16;
       access rw;
       reset 16'h0;
    }
  }
  register SequenceReg0b53s1 @'hc9 {
    field SequenceReg0b53s1 @0 {
       bits 16;
       access rw;
       reset 16'h0;
    }
  }
  register SequenceReg0b53s2 @'hca {
    field SequenceReg0b53s2 @0 {
       bits 9;
       access rw;
       reset 9'h0;
    }
  }
  register SequenceReg0b54s0 @'hcb {
    field SequenceReg0b54s0 @0 {
       bits 16;
       access rw;
       reset 16'h0;
    }
  }
  register SequenceReg0b54s1 @'hcc {
    field SequenceReg0b54s1 @0 {
       bits 16;
       access rw;
       reset 16'h0;
    }
  }
  register SequenceReg0b54s2 @'hcd {
    field SequenceReg0b54s2 @0 {
       bits 9;
       access rw;
       reset 9'h0;
    }
  }
  register SequenceReg0b55s0 @'hce {
    field SequenceReg0b55s0 @0 {
       bits 16;
       access rw;
       reset 16'h0;
    }
  }
  register SequenceReg0b55s1 @'hcf {
    field SequenceReg0b55s1 @0 {
       bits 16;
       access rw;
       reset 16'h0;
    }
  }
  register SequenceReg0b55s2 @'hd0 {
    field SequenceReg0b55s2 @0 {
       bits 9;
       access rw;
       reset 9'h0;
    }
  }
  register SequenceReg0b56s0 @'hd1 {
    field SequenceReg0b56s0 @0 {
       bits 16;
       access rw;
       reset 16'h0;
    }
  }
  register SequenceReg0b56s1 @'hd2 {
    field SequenceReg0b56s1 @0 {
       bits 16;
       access rw;
       reset 16'h0;
    }
  }
  register SequenceReg0b56s2 @'hd3 {
    field SequenceReg0b56s2 @0 {
       bits 9;
       access rw;
       reset 9'h0;
    }
  }
  register SequenceReg0b57s0 @'hd4 {
    field SequenceReg0b57s0 @0 {
       bits 16;
       access rw;
       reset 16'h0;
    }
  }
  register SequenceReg0b57s1 @'hd5 {
    field SequenceReg0b57s1 @0 {
       bits 16;
       access rw;
       reset 16'h0;
    }
  }
  register SequenceReg0b57s2 @'hd6 {
    field SequenceReg0b57s2 @0 {
       bits 9;
       access rw;
       reset 9'h0;
    }
  }
  register SequenceReg0b58s0 @'hd7 {
    field SequenceReg0b58s0 @0 {
       bits 16;
       access rw;
       reset 16'h0;
    }
  }
  register SequenceReg0b58s1 @'hd8 {
    field SequenceReg0b58s1 @0 {
       bits 16;
       access rw;
       reset 16'h0;
    }
  }
  register SequenceReg0b58s2 @'hd9 {
    field SequenceReg0b58s2 @0 {
       bits 9;
       access rw;
       reset 9'h0;
    }
  }
  register SequenceReg0b59s0 @'hda {
    field SequenceReg0b59s0 @0 {
       bits 16;
       access rw;
       reset 16'h0;
    }
  }
  register SequenceReg0b59s1 @'hdb {
    field SequenceReg0b59s1 @0 {
       bits 16;
       access rw;
       reset 16'h0;
    }
  }
  register SequenceReg0b59s2 @'hdc {
    field SequenceReg0b59s2 @0 {
       bits 9;
       access rw;
       reset 9'h0;
    }
  }
  register SequenceReg0b60s0 @'hdd {
    field SequenceReg0b60s0 @0 {
       bits 16;
       access rw;
       reset 16'h0;
    }
  }
  register SequenceReg0b60s1 @'hde {
    field SequenceReg0b60s1 @0 {
       bits 16;
       access rw;
       reset 16'h0;
    }
  }
  register SequenceReg0b60s2 @'hdf {
    field SequenceReg0b60s2 @0 {
       bits 9;
       access rw;
       reset 9'h0;
    }
  }
  register SequenceReg0b61s0 @'he0 {
    field SequenceReg0b61s0 @0 {
       bits 16;
       access rw;
       reset 16'h0;
    }
  }
  register SequenceReg0b61s1 @'he1 {
    field SequenceReg0b61s1 @0 {
       bits 16;
       access rw;
       reset 16'h0;
    }
  }
  register SequenceReg0b61s2 @'he2 {
    field SequenceReg0b61s2 @0 {
       bits 9;
       access rw;
       reset 9'h0;
    }
  }
  register SequenceReg0b62s0 @'he3 {
    field SequenceReg0b62s0 @0 {
       bits 16;
       access rw;
       reset 16'h0;
    }
  }
  register SequenceReg0b62s1 @'he4 {
    field SequenceReg0b62s1 @0 {
       bits 16;
       access rw;
       reset 16'h0;
    }
  }
  register SequenceReg0b62s2 @'he5 {
    field SequenceReg0b62s2 @0 {
       bits 9;
       access rw;
       reset 9'h0;
    }
  }
  register SequenceReg0b63s0 @'he6 {
    field SequenceReg0b63s0 @0 {
       bits 16;
       access rw;
       reset 16'h0;
    }
  }
  register SequenceReg0b63s1 @'he7 {
    field SequenceReg0b63s1 @0 {
       bits 16;
       access rw;
       reset 16'h0;
    }
  }
  register SequenceReg0b63s2 @'he8 {
    field SequenceReg0b63s2 @0 {
       bits 9;
       access rw;
       reset 9'h0;
    }
  }
  register SequenceReg0b64s0 @'he9 {
    field SequenceReg0b64s0 @0 {
       bits 16;
       access rw;
       reset 16'h0;
    }
  }
  register SequenceReg0b64s1 @'hea {
    field SequenceReg0b64s1 @0 {
       bits 16;
       access rw;
       reset 16'h0;
    }
  }
  register SequenceReg0b64s2 @'heb {
    field SequenceReg0b64s2 @0 {
       bits 9;
       access rw;
       reset 9'h0;
    }
  }
  register SequenceReg0b65s0 @'hec {
    field SequenceReg0b65s0 @0 {
       bits 16;
       access rw;
       reset 16'h0;
    }
  }
  register SequenceReg0b65s1 @'hed {
    field SequenceReg0b65s1 @0 {
       bits 16;
       access rw;
       reset 16'h0;
    }
  }
  register SequenceReg0b65s2 @'hee {
    field SequenceReg0b65s2 @0 {
       bits 9;
       access rw;
       reset 9'h0;
    }
  }
  register SequenceReg0b66s0 @'hef {
    field SequenceReg0b66s0 @0 {
       bits 16;
       access rw;
       reset 16'h0;
    }
  }
  register SequenceReg0b66s1 @'hf0 {
    field SequenceReg0b66s1 @0 {
       bits 16;
       access rw;
       reset 16'h0;
    }
  }
  register SequenceReg0b66s2 @'hf1 {
    field SequenceReg0b66s2 @0 {
       bits 9;
       access rw;
       reset 9'h0;
    }
  }
  register SequenceReg0b67s0 @'hf2 {
    field SequenceReg0b67s0 @0 {
       bits 16;
       access rw;
       reset 16'h0;
    }
  }
  register SequenceReg0b67s1 @'hf3 {
    field SequenceReg0b67s1 @0 {
       bits 16;
       access rw;
       reset 16'h0;
    }
  }
  register SequenceReg0b67s2 @'hf4 {
    field SequenceReg0b67s2 @0 {
       bits 9;
       access rw;
       reset 9'h0;
    }
  }
  register SequenceReg0b68s0 @'hf5 {
    field SequenceReg0b68s0 @0 {
       bits 16;
       access rw;
       reset 16'h0;
    }
  }
  register SequenceReg0b68s1 @'hf6 {
    field SequenceReg0b68s1 @0 {
       bits 16;
       access rw;
       reset 16'h0;
    }
  }
  register SequenceReg0b68s2 @'hf7 {
    field SequenceReg0b68s2 @0 {
       bits 9;
       access rw;
       reset 9'h0;
    }
  }
  register SequenceReg0b69s0 @'hf8 {
    field SequenceReg0b69s0 @0 {
       bits 16;
       access rw;
       reset 16'h0;
    }
  }
  register SequenceReg0b69s1 @'hf9 {
    field SequenceReg0b69s1 @0 {
       bits 16;
       access rw;
       reset 16'h0;
    }
  }
  register SequenceReg0b69s2 @'hfa {
    field SequenceReg0b69s2 @0 {
       bits 9;
       access rw;
       reset 9'h0;
    }
  }
  register SequenceReg0b70s0 @'hfb {
    field SequenceReg0b70s0 @0 {
       bits 16;
       access rw;
       reset 16'h0;
    }
  }
  register SequenceReg0b70s1 @'hfc {
    field SequenceReg0b70s1 @0 {
       bits 16;
       access rw;
       reset 16'h0;
    }
  }
  register SequenceReg0b70s2 @'hfd {
    field SequenceReg0b70s2 @0 {
       bits 9;
       access rw;
       reset 9'h0;
    }
  }
  register SequenceReg0b71s0 @'hfe {
    field SequenceReg0b71s0 @0 {
       bits 16;
       access rw;
       reset 16'h0;
    }
  }
  register SequenceReg0b71s1 @'hff {
    field SequenceReg0b71s1 @0 {
       bits 16;
       access rw;
       reset 16'h0;
    }
  }
  register SequenceReg0b71s2 @'h100 {
    field SequenceReg0b71s2 @0 {
       bits 9;
       access rw;
       reset 9'h0;
    }
  }
  register SequenceReg0b72s0 @'h101 {
    field SequenceReg0b72s0 @0 {
       bits 16;
       access rw;
       reset 16'h0;
    }
  }
  register SequenceReg0b72s1 @'h102 {
    field SequenceReg0b72s1 @0 {
       bits 16;
       access rw;
       reset 16'h0;
    }
  }
  register SequenceReg0b72s2 @'h103 {
    field SequenceReg0b72s2 @0 {
       bits 9;
       access rw;
       reset 9'h0;
    }
  }
  register SequenceReg0b73s0 @'h104 {
    field SequenceReg0b73s0 @0 {
       bits 16;
       access rw;
       reset 16'h0;
    }
  }
  register SequenceReg0b73s1 @'h105 {
    field SequenceReg0b73s1 @0 {
       bits 16;
       access rw;
       reset 16'h0;
    }
  }
  register SequenceReg0b73s2 @'h106 {
    field SequenceReg0b73s2 @0 {
       bits 9;
       access rw;
       reset 9'h0;
    }
  }
  register SequenceReg0b74s0 @'h107 {
    field SequenceReg0b74s0 @0 {
       bits 16;
       access rw;
       reset 16'h0;
    }
  }
  register SequenceReg0b74s1 @'h108 {
    field SequenceReg0b74s1 @0 {
       bits 16;
       access rw;
       reset 16'h0;
    }
  }
  register SequenceReg0b74s2 @'h109 {
    field SequenceReg0b74s2 @0 {
       bits 9;
       access rw;
       reset 9'h0;
    }
  }
  register SequenceReg0b75s0 @'h10a {
    field SequenceReg0b75s0 @0 {
       bits 16;
       access rw;
       reset 16'h0;
    }
  }
  register SequenceReg0b75s1 @'h10b {
    field SequenceReg0b75s1 @0 {
       bits 16;
       access rw;
       reset 16'h0;
    }
  }
  register SequenceReg0b75s2 @'h10c {
    field SequenceReg0b75s2 @0 {
       bits 9;
       access rw;
       reset 9'h0;
    }
  }
  register SequenceReg0b76s0 @'h10d {
    field SequenceReg0b76s0 @0 {
       bits 16;
       access rw;
       reset 16'h0;
    }
  }
  register SequenceReg0b76s1 @'h10e {
    field SequenceReg0b76s1 @0 {
       bits 16;
       access rw;
       reset 16'h0;
    }
  }
  register SequenceReg0b76s2 @'h10f {
    field SequenceReg0b76s2 @0 {
       bits 9;
       access rw;
       reset 9'h0;
    }
  }
  register SequenceReg0b77s0 @'h110 {
    field SequenceReg0b77s0 @0 {
       bits 16;
       access rw;
       reset 16'h0;
    }
  }
  register SequenceReg0b77s1 @'h111 {
    field SequenceReg0b77s1 @0 {
       bits 16;
       access rw;
       reset 16'h0;
    }
  }
  register SequenceReg0b77s2 @'h112 {
    field SequenceReg0b77s2 @0 {
       bits 9;
       access rw;
       reset 9'h0;
    }
  }
  register SequenceReg0b78s0 @'h113 {
    field SequenceReg0b78s0 @0 {
       bits 16;
       access rw;
       reset 16'h0;
    }
  }
  register SequenceReg0b78s1 @'h114 {
    field SequenceReg0b78s1 @0 {
       bits 16;
       access rw;
       reset 16'h0;
    }
  }
  register SequenceReg0b78s2 @'h115 {
    field SequenceReg0b78s2 @0 {
       bits 9;
       access rw;
       reset 9'h0;
    }
  }
  register SequenceReg0b79s0 @'h116 {
    field SequenceReg0b79s0 @0 {
       bits 16;
       access rw;
       reset 16'h0;
    }
  }
  register SequenceReg0b79s1 @'h117 {
    field SequenceReg0b79s1 @0 {
       bits 16;
       access rw;
       reset 16'h0;
    }
  }
  register SequenceReg0b79s2 @'h118 {
    field SequenceReg0b79s2 @0 {
       bits 9;
       access rw;
       reset 9'h0;
    }
  }
  register SequenceReg0b80s0 @'h119 {
    field SequenceReg0b80s0 @0 {
       bits 16;
       access rw;
       reset 16'h0;
    }
  }
  register SequenceReg0b80s1 @'h11a {
    field SequenceReg0b80s1 @0 {
       bits 16;
       access rw;
       reset 16'h0;
    }
  }
  register SequenceReg0b80s2 @'h11b {
    field SequenceReg0b80s2 @0 {
       bits 9;
       access rw;
       reset 9'h0;
    }
  }
  register SequenceReg0b81s0 @'h11c {
    field SequenceReg0b81s0 @0 {
       bits 16;
       access rw;
       reset 16'h0;
    }
  }
  register SequenceReg0b81s1 @'h11d {
    field SequenceReg0b81s1 @0 {
       bits 16;
       access rw;
       reset 16'h0;
    }
  }
  register SequenceReg0b81s2 @'h11e {
    field SequenceReg0b81s2 @0 {
       bits 9;
       access rw;
       reset 9'h0;
    }
  }
  register SequenceReg0b82s0 @'h11f {
    field SequenceReg0b82s0 @0 {
       bits 16;
       access rw;
       reset 16'h0;
    }
  }
  register SequenceReg0b82s1 @'h120 {
    field SequenceReg0b82s1 @0 {
       bits 16;
       access rw;
       reset 16'h0;
    }
  }
  register SequenceReg0b82s2 @'h121 {
    field SequenceReg0b82s2 @0 {
       bits 9;
       access rw;
       reset 9'h0;
    }
  }
  register SequenceReg0b83s0 @'h122 {
    field SequenceReg0b83s0 @0 {
       bits 16;
       access rw;
       reset 16'h0;
    }
  }
  register SequenceReg0b83s1 @'h123 {
    field SequenceReg0b83s1 @0 {
       bits 16;
       access rw;
       reset 16'h0;
    }
  }
  register SequenceReg0b83s2 @'h124 {
    field SequenceReg0b83s2 @0 {
       bits 9;
       access rw;
       reset 9'h0;
    }
  }
  register SequenceReg0b84s0 @'h125 {
    field SequenceReg0b84s0 @0 {
       bits 16;
       access rw;
       reset 16'h0;
    }
  }
  register SequenceReg0b84s1 @'h126 {
    field SequenceReg0b84s1 @0 {
       bits 16;
       access rw;
       reset 16'h0;
    }
  }
  register SequenceReg0b84s2 @'h127 {
    field SequenceReg0b84s2 @0 {
       bits 9;
       access rw;
       reset 9'h0;
    }
  }
  register SequenceReg0b85s0 @'h128 {
    field SequenceReg0b85s0 @0 {
       bits 16;
       access rw;
       reset 16'h0;
    }
  }
  register SequenceReg0b85s1 @'h129 {
    field SequenceReg0b85s1 @0 {
       bits 16;
       access rw;
       reset 16'h0;
    }
  }
  register SequenceReg0b85s2 @'h12a {
    field SequenceReg0b85s2 @0 {
       bits 9;
       access rw;
       reset 9'h0;
    }
  }
  register SequenceReg0b86s0 @'h12b {
    field SequenceReg0b86s0 @0 {
       bits 16;
       access rw;
       reset 16'h0;
    }
  }
  register SequenceReg0b86s1 @'h12c {
    field SequenceReg0b86s1 @0 {
       bits 16;
       access rw;
       reset 16'h0;
    }
  }
  register SequenceReg0b86s2 @'h12d {
    field SequenceReg0b86s2 @0 {
       bits 9;
       access rw;
       reset 9'h0;
    }
  }
  register SequenceReg0b87s0 @'h12e {
    field SequenceReg0b87s0 @0 {
       bits 16;
       access rw;
       reset 16'h0;
    }
  }
  register SequenceReg0b87s1 @'h12f {
    field SequenceReg0b87s1 @0 {
       bits 16;
       access rw;
       reset 16'h0;
    }
  }
  register SequenceReg0b87s2 @'h130 {
    field SequenceReg0b87s2 @0 {
       bits 9;
       access rw;
       reset 9'h0;
    }
  }
  register SequenceReg0b88s0 @'h131 {
    field SequenceReg0b88s0 @0 {
       bits 16;
       access rw;
       reset 16'h0;
    }
  }
  register SequenceReg0b88s1 @'h132 {
    field SequenceReg0b88s1 @0 {
       bits 16;
       access rw;
       reset 16'h0;
    }
  }
  register SequenceReg0b88s2 @'h133 {
    field SequenceReg0b88s2 @0 {
       bits 9;
       access rw;
       reset 9'h0;
    }
  }
  register SequenceReg0b89s0 @'h134 {
    field SequenceReg0b89s0 @0 {
       bits 16;
       access rw;
       reset 16'h0;
    }
  }
  register SequenceReg0b89s1 @'h135 {
    field SequenceReg0b89s1 @0 {
       bits 16;
       access rw;
       reset 16'h0;
    }
  }
  register SequenceReg0b89s2 @'h136 {
    field SequenceReg0b89s2 @0 {
       bits 9;
       access rw;
       reset 9'h0;
    }
  }
  register SequenceReg0b90s0 @'h137 {
    field SequenceReg0b90s0 @0 {
       bits 16;
       access rw;
       reset 16'h0;
    }
  }
  register SequenceReg0b90s1 @'h138 {
    field SequenceReg0b90s1 @0 {
       bits 16;
       access rw;
       reset 16'h0;
    }
  }
  register SequenceReg0b90s2 @'h139 {
    field SequenceReg0b90s2 @0 {
       bits 9;
       access rw;
       reset 9'h0;
    }
  }
  register SequenceReg0b91s0 @'h13a {
    field SequenceReg0b91s0 @0 {
       bits 16;
       access rw;
       reset 16'h0;
    }
  }
  register SequenceReg0b91s1 @'h13b {
    field SequenceReg0b91s1 @0 {
       bits 16;
       access rw;
       reset 16'h0;
    }
  }
  register SequenceReg0b91s2 @'h13c {
    field SequenceReg0b91s2 @0 {
       bits 9;
       access rw;
       reset 9'h0;
    }
  }
  register SequenceReg0b92s0 @'h13d {
    field SequenceReg0b92s0 @0 {
       bits 16;
       access rw;
       reset 16'h0;
    }
  }
  register SequenceReg0b92s1 @'h13e {
    field SequenceReg0b92s1 @0 {
       bits 16;
       access rw;
       reset 16'h0;
    }
  }
  register SequenceReg0b92s2 @'h13f {
    field SequenceReg0b92s2 @0 {
       bits 9;
       access rw;
       reset 9'h0;
    }
  }
  register SequenceReg0b93s0 @'h140 {
    field SequenceReg0b93s0 @0 {
       bits 16;
       access rw;
       reset 16'h0;
    }
  }
  register SequenceReg0b93s1 @'h141 {
    field SequenceReg0b93s1 @0 {
       bits 16;
       access rw;
       reset 16'h0;
    }
  }
  register SequenceReg0b93s2 @'h142 {
    field SequenceReg0b93s2 @0 {
       bits 9;
       access rw;
       reset 9'h0;
    }
  }
  register SequenceReg0b94s0 @'h143 {
    field SequenceReg0b94s0 @0 {
       bits 16;
       access rw;
       reset 16'h0;
    }
  }
  register SequenceReg0b94s1 @'h144 {
    field SequenceReg0b94s1 @0 {
       bits 16;
       access rw;
       reset 16'h0;
    }
  }
  register SequenceReg0b94s2 @'h145 {
    field SequenceReg0b94s2 @0 {
       bits 9;
       access rw;
       reset 9'h0;
    }
  }
  register SequenceReg0b95s0 @'h146 {
    field SequenceReg0b95s0 @0 {
       bits 16;
       access rw;
       reset 16'h0;
    }
  }
  register SequenceReg0b95s1 @'h147 {
    field SequenceReg0b95s1 @0 {
       bits 16;
       access rw;
       reset 16'h0;
    }
  }
  register SequenceReg0b95s2 @'h148 {
    field SequenceReg0b95s2 @0 {
       bits 9;
       access rw;
       reset 9'h0;
    }
  }
  register SequenceReg0b96s0 @'h149 {
    field SequenceReg0b96s0 @0 {
       bits 16;
       access rw;
       reset 16'h0;
    }
  }
  register SequenceReg0b96s1 @'h14a {
    field SequenceReg0b96s1 @0 {
       bits 16;
       access rw;
       reset 16'h0;
    }
  }
  register SequenceReg0b96s2 @'h14b {
    field SequenceReg0b96s2 @0 {
       bits 9;
       access rw;
       reset 9'h0;
    }
  }
  register SequenceReg0b97s0 @'h14c {
    field SequenceReg0b97s0 @0 {
       bits 16;
       access rw;
       reset 16'h0;
    }
  }
  register SequenceReg0b97s1 @'h14d {
    field SequenceReg0b97s1 @0 {
       bits 16;
       access rw;
       reset 16'h0;
    }
  }
  register SequenceReg0b97s2 @'h14e {
    field SequenceReg0b97s2 @0 {
       bits 9;
       access rw;
       reset 9'h0;
    }
  }
  register SequenceReg0b98s0 @'h14f {
    field SequenceReg0b98s0 @0 {
       bits 16;
       access rw;
       reset 16'h0;
    }
  }
  register SequenceReg0b98s1 @'h150 {
    field SequenceReg0b98s1 @0 {
       bits 16;
       access rw;
       reset 16'h0;
    }
  }
  register SequenceReg0b98s2 @'h151 {
    field SequenceReg0b98s2 @0 {
       bits 9;
       access rw;
       reset 9'h0;
    }
  }
  register SequenceReg0b99s0 @'h152 {
    field SequenceReg0b99s0 @0 {
       bits 16;
       access rw;
       reset 16'h0;
    }
  }
  register SequenceReg0b99s1 @'h153 {
    field SequenceReg0b99s1 @0 {
       bits 16;
       access rw;
       reset 16'h0;
    }
  }
  register SequenceReg0b99s2 @'h154 {
    field SequenceReg0b99s2 @0 {
       bits 9;
       access rw;
       reset 9'h0;
    }
  }
  register SequenceReg0b100s0 @'h155 {
    field SequenceReg0b100s0 @0 {
       bits 16;
       access rw;
       reset 16'h0;
    }
  }
  register SequenceReg0b100s1 @'h156 {
    field SequenceReg0b100s1 @0 {
       bits 16;
       access rw;
       reset 16'h0;
    }
  }
  register SequenceReg0b100s2 @'h157 {
    field SequenceReg0b100s2 @0 {
       bits 9;
       access rw;
       reset 9'h0;
    }
  }
  register SequenceReg0b101s0 @'h158 {
    field SequenceReg0b101s0 @0 {
       bits 16;
       access rw;
       reset 16'h0;
    }
  }
  register SequenceReg0b101s1 @'h159 {
    field SequenceReg0b101s1 @0 {
       bits 16;
       access rw;
       reset 16'h0;
    }
  }
  register SequenceReg0b101s2 @'h15a {
    field SequenceReg0b101s2 @0 {
       bits 9;
       access rw;
       reset 9'h0;
    }
  }
  register SequenceReg0b102s0 @'h15b {
    field SequenceReg0b102s0 @0 {
       bits 16;
       access rw;
       reset 16'h0;
    }
  }
  register SequenceReg0b102s1 @'h15c {
    field SequenceReg0b102s1 @0 {
       bits 16;
       access rw;
       reset 16'h0;
    }
  }
  register SequenceReg0b102s2 @'h15d {
    field SequenceReg0b102s2 @0 {
       bits 9;
       access rw;
       reset 9'h0;
    }
  }
  register SequenceReg0b103s0 @'h15e {
    field SequenceReg0b103s0 @0 {
       bits 16;
       access rw;
       reset 16'h0;
    }
  }
  register SequenceReg0b103s1 @'h15f {
    field SequenceReg0b103s1 @0 {
       bits 16;
       access rw;
       reset 16'h0;
    }
  }
  register SequenceReg0b103s2 @'h160 {
    field SequenceReg0b103s2 @0 {
       bits 9;
       access rw;
       reset 9'h0;
    }
  }
  register SequenceReg0b104s0 @'h161 {
    field SequenceReg0b104s0 @0 {
       bits 16;
       access rw;
       reset 16'h0;
    }
  }
  register SequenceReg0b104s1 @'h162 {
    field SequenceReg0b104s1 @0 {
       bits 16;
       access rw;
       reset 16'h0;
    }
  }
  register SequenceReg0b104s2 @'h163 {
    field SequenceReg0b104s2 @0 {
       bits 9;
       access rw;
       reset 9'h0;
    }
  }
  register SequenceReg0b105s0 @'h164 {
    field SequenceReg0b105s0 @0 {
       bits 16;
       access rw;
       reset 16'h0;
    }
  }
  register SequenceReg0b105s1 @'h165 {
    field SequenceReg0b105s1 @0 {
       bits 16;
       access rw;
       reset 16'h0;
    }
  }
  register SequenceReg0b105s2 @'h166 {
    field SequenceReg0b105s2 @0 {
       bits 9;
       access rw;
       reset 9'h0;
    }
  }
  register SequenceReg0b106s0 @'h167 {
    field SequenceReg0b106s0 @0 {
       bits 16;
       access rw;
       reset 16'h0;
    }
  }
  register SequenceReg0b106s1 @'h168 {
    field SequenceReg0b106s1 @0 {
       bits 16;
       access rw;
       reset 16'h0;
    }
  }
  register SequenceReg0b106s2 @'h169 {
    field SequenceReg0b106s2 @0 {
       bits 9;
       access rw;
       reset 9'h0;
    }
  }
  register SequenceReg0b107s0 @'h16a {
    field SequenceReg0b107s0 @0 {
       bits 16;
       access rw;
       reset 16'h0;
    }
  }
  register SequenceReg0b107s1 @'h16b {
    field SequenceReg0b107s1 @0 {
       bits 16;
       access rw;
       reset 16'h0;
    }
  }
  register SequenceReg0b107s2 @'h16c {
    field SequenceReg0b107s2 @0 {
       bits 9;
       access rw;
       reset 9'h0;
    }
  }
  register SequenceReg0b108s0 @'h16d {
    field SequenceReg0b108s0 @0 {
       bits 16;
       access rw;
       reset 16'h0;
    }
  }
  register SequenceReg0b108s1 @'h16e {
    field SequenceReg0b108s1 @0 {
       bits 16;
       access rw;
       reset 16'h0;
    }
  }
  register SequenceReg0b108s2 @'h16f {
    field SequenceReg0b108s2 @0 {
       bits 9;
       access rw;
       reset 9'h0;
    }
  }
  register SequenceReg0b109s0 @'h170 {
    field SequenceReg0b109s0 @0 {
       bits 16;
       access rw;
       reset 16'h0;
    }
  }
  register SequenceReg0b109s1 @'h171 {
    field SequenceReg0b109s1 @0 {
       bits 16;
       access rw;
       reset 16'h0;
    }
  }
  register SequenceReg0b109s2 @'h172 {
    field SequenceReg0b109s2 @0 {
       bits 9;
       access rw;
       reset 9'h0;
    }
  }
  register SequenceReg0b110s0 @'h173 {
    field SequenceReg0b110s0 @0 {
       bits 16;
       access rw;
       reset 16'h0;
    }
  }
  register SequenceReg0b110s1 @'h174 {
    field SequenceReg0b110s1 @0 {
       bits 16;
       access rw;
       reset 16'h0;
    }
  }
  register SequenceReg0b110s2 @'h175 {
    field SequenceReg0b110s2 @0 {
       bits 9;
       access rw;
       reset 9'h0;
    }
  }
  register SequenceReg0b111s0 @'h176 {
    field SequenceReg0b111s0 @0 {
       bits 16;
       access rw;
       reset 16'h0;
    }
  }
  register SequenceReg0b111s1 @'h177 {
    field SequenceReg0b111s1 @0 {
       bits 16;
       access rw;
       reset 16'h0;
    }
  }
  register SequenceReg0b111s2 @'h178 {
    field SequenceReg0b111s2 @0 {
       bits 9;
       access rw;
       reset 9'h0;
    }
  }
  register SequenceReg0b112s0 @'h179 {
    field SequenceReg0b112s0 @0 {
       bits 16;
       access rw;
       reset 16'h0;
    }
  }
  register SequenceReg0b112s1 @'h17a {
    field SequenceReg0b112s1 @0 {
       bits 16;
       access rw;
       reset 16'h0;
    }
  }
  register SequenceReg0b112s2 @'h17b {
    field SequenceReg0b112s2 @0 {
       bits 9;
       access rw;
       reset 9'h0;
    }
  }
  register SequenceReg0b113s0 @'h17c {
    field SequenceReg0b113s0 @0 {
       bits 16;
       access rw;
       reset 16'h0;
    }
  }
  register SequenceReg0b113s1 @'h17d {
    field SequenceReg0b113s1 @0 {
       bits 16;
       access rw;
       reset 16'h0;
    }
  }
  register SequenceReg0b113s2 @'h17e {
    field SequenceReg0b113s2 @0 {
       bits 9;
       access rw;
       reset 9'h0;
    }
  }
  register SequenceReg0b114s0 @'h17f {
    field SequenceReg0b114s0 @0 {
       bits 16;
       access rw;
       reset 16'h0;
    }
  }
  register SequenceReg0b114s1 @'h180 {
    field SequenceReg0b114s1 @0 {
       bits 16;
       access rw;
       reset 16'h0;
    }
  }
  register SequenceReg0b114s2 @'h181 {
    field SequenceReg0b114s2 @0 {
       bits 9;
       access rw;
       reset 9'h0;
    }
  }
  register SequenceReg0b115s0 @'h182 {
    field SequenceReg0b115s0 @0 {
       bits 16;
       access rw;
       reset 16'h0;
    }
  }
  register SequenceReg0b115s1 @'h183 {
    field SequenceReg0b115s1 @0 {
       bits 16;
       access rw;
       reset 16'h0;
    }
  }
  register SequenceReg0b115s2 @'h184 {
    field SequenceReg0b115s2 @0 {
       bits 9;
       access rw;
       reset 9'h0;
    }
  }
  register SequenceReg0b116s0 @'h185 {
    field SequenceReg0b116s0 @0 {
       bits 16;
       access rw;
       reset 16'h0;
    }
  }
  register SequenceReg0b116s1 @'h186 {
    field SequenceReg0b116s1 @0 {
       bits 16;
       access rw;
       reset 16'h0;
    }
  }
  register SequenceReg0b116s2 @'h187 {
    field SequenceReg0b116s2 @0 {
       bits 9;
       access rw;
       reset 9'h0;
    }
  }
  register SequenceReg0b117s0 @'h188 {
    field SequenceReg0b117s0 @0 {
       bits 16;
       access rw;
       reset 16'h0;
    }
  }
  register SequenceReg0b117s1 @'h189 {
    field SequenceReg0b117s1 @0 {
       bits 16;
       access rw;
       reset 16'h0;
    }
  }
  register SequenceReg0b117s2 @'h18a {
    field SequenceReg0b117s2 @0 {
       bits 9;
       access rw;
       reset 9'h0;
    }
  }
  register SequenceReg0b118s0 @'h18b {
    field SequenceReg0b118s0 @0 {
       bits 16;
       access rw;
       reset 16'h0;
    }
  }
  register SequenceReg0b118s1 @'h18c {
    field SequenceReg0b118s1 @0 {
       bits 16;
       access rw;
       reset 16'h0;
    }
  }
  register SequenceReg0b118s2 @'h18d {
    field SequenceReg0b118s2 @0 {
       bits 9;
       access rw;
       reset 9'h0;
    }
  }
  register SequenceReg0b119s0 @'h18e {
    field SequenceReg0b119s0 @0 {
       bits 16;
       access rw;
       reset 16'h0;
    }
  }
  register SequenceReg0b119s1 @'h18f {
    field SequenceReg0b119s1 @0 {
       bits 16;
       access rw;
       reset 16'h0;
    }
  }
  register SequenceReg0b119s2 @'h190 {
    field SequenceReg0b119s2 @0 {
       bits 9;
       access rw;
       reset 9'h0;
    }
  }
  register SequenceReg0b120s0 @'h191 {
    field SequenceReg0b120s0 @0 {
       bits 16;
       access rw;
       reset 16'h0;
    }
  }
  register SequenceReg0b120s1 @'h192 {
    field SequenceReg0b120s1 @0 {
       bits 16;
       access rw;
       reset 16'h0;
    }
  }
  register SequenceReg0b120s2 @'h193 {
    field SequenceReg0b120s2 @0 {
       bits 9;
       access rw;
       reset 9'h0;
    }
  }
  register SequenceReg0b121s0 @'h194 {
    field SequenceReg0b121s0 @0 {
       bits 16;
       access rw;
       reset 16'h0;
    }
  }
  register SequenceReg0b121s1 @'h195 {
    field SequenceReg0b121s1 @0 {
       bits 16;
       access rw;
       reset 16'h0;
    }
  }
  register SequenceReg0b121s2 @'h196 {
    field SequenceReg0b121s2 @0 {
       bits 9;
       access rw;
       reset 9'h0;
    }
  }
  register Seq0BGPR1_p0 @'h201 {
    field Seq0BGPR1_p0 @0 {
       bits 16;
       access rw;
       reset 16'h0;
    }
  }
  register Seq0BGPR2_p0 @'h202 {
    field Seq0BGPR2_p0 @0 {
       bits 16;
       access rw;
       reset 16'h0;
    }
  }
  register Seq0BGPR3_p0 @'h203 {
    field Seq0BGPR3_p0 @0 {
       bits 16;
       access rw;
       reset 16'h0;
    }
  }
  register Seq0BGPR4_p0 @'h204 {
    field Seq0BGPR4_p0 @0 {
       bits 16;
       access rw;
       reset 16'h0;
    }
  }
  register Seq0BGPR5_p0 @'h205 {
    field Seq0BGPR5_p0 @0 {
       bits 16;
       access rw;
       reset 16'h0;
    }
  }
  register Seq0BGPR6_p0 @'h206 {
    field Seq0BGPR6_p0 @0 {
       bits 16;
       access rw;
       reset 16'h0;
    }
  }
  register Seq0BGPR7_p0 @'h207 {
    field Seq0BGPR7_p0 @0 {
       bits 16;
       access rw;
       reset 16'h0;
    }
  }
  register Seq0BGPR8_p0 @'h208 {
    field Seq0BGPR8_p0 @0 {
       bits 16;
       access rw;
       reset 16'h0;
    }
  }
  register Seq0BFixedAddrBits @'h2ff {
    field RFU_Seq0BFixedAddrBits @0 {
       bits 7;
       access rw;
       reset 7'hf;
    }
  }
  register Seq0BGPR1_p1 @'h100201 {
    field Seq0BGPR1_p1 @0 {
       bits 16;
       access rw;
       reset 16'h0;
    }
  }
  register Seq0BGPR2_p1 @'h100202 {
    field Seq0BGPR2_p1 @0 {
       bits 16;
       access rw;
       reset 16'h0;
    }
  }
  register Seq0BGPR3_p1 @'h100203 {
    field Seq0BGPR3_p1 @0 {
       bits 16;
       access rw;
       reset 16'h0;
    }
  }
  register Seq0BGPR4_p1 @'h100204 {
    field Seq0BGPR4_p1 @0 {
       bits 16;
       access rw;
       reset 16'h0;
    }
  }
  register Seq0BGPR5_p1 @'h100205 {
    field Seq0BGPR5_p1 @0 {
       bits 16;
       access rw;
       reset 16'h0;
    }
  }
  register Seq0BGPR6_p1 @'h100206 {
    field Seq0BGPR6_p1 @0 {
       bits 16;
       access rw;
       reset 16'h0;
    }
  }
  register Seq0BGPR7_p1 @'h100207 {
    field Seq0BGPR7_p1 @0 {
       bits 16;
       access rw;
       reset 16'h0;
    }
  }
  register Seq0BGPR8_p1 @'h100208 {
    field Seq0BGPR8_p1 @0 {
       bits 16;
       access rw;
       reset 16'h0;
    }
  }
  register Seq0BGPR1_p2 @'h200201 {
    field Seq0BGPR1_p2 @0 {
       bits 16;
       access rw;
       reset 16'h0;
    }
  }
  register Seq0BGPR2_p2 @'h200202 {
    field Seq0BGPR2_p2 @0 {
       bits 16;
       access rw;
       reset 16'h0;
    }
  }
  register Seq0BGPR3_p2 @'h200203 {
    field Seq0BGPR3_p2 @0 {
       bits 16;
       access rw;
       reset 16'h0;
    }
  }
  register Seq0BGPR4_p2 @'h200204 {
    field Seq0BGPR4_p2 @0 {
       bits 16;
       access rw;
       reset 16'h0;
    }
  }
  register Seq0BGPR5_p2 @'h200205 {
    field Seq0BGPR5_p2 @0 {
       bits 16;
       access rw;
       reset 16'h0;
    }
  }
  register Seq0BGPR6_p2 @'h200206 {
    field Seq0BGPR6_p2 @0 {
       bits 16;
       access rw;
       reset 16'h0;
    }
  }
  register Seq0BGPR7_p2 @'h200207 {
    field Seq0BGPR7_p2 @0 {
       bits 16;
       access rw;
       reset 16'h0;
    }
  }
  register Seq0BGPR8_p2 @'h200208 {
    field Seq0BGPR8_p2 @0 {
       bits 16;
       access rw;
       reset 16'h0;
    }
  }
  register Seq0BGPR1_p3 @'h300201 {
    field Seq0BGPR1_p3 @0 {
       bits 16;
       access rw;
       reset 16'h0;
    }
  }
  register Seq0BGPR2_p3 @'h300202 {
    field Seq0BGPR2_p3 @0 {
       bits 16;
       access rw;
       reset 16'h0;
    }
  }
  register Seq0BGPR3_p3 @'h300203 {
    field Seq0BGPR3_p3 @0 {
       bits 16;
       access rw;
       reset 16'h0;
    }
  }
  register Seq0BGPR4_p3 @'h300204 {
    field Seq0BGPR4_p3 @0 {
       bits 16;
       access rw;
       reset 16'h0;
    }
  }
  register Seq0BGPR5_p3 @'h300205 {
    field Seq0BGPR5_p3 @0 {
       bits 16;
       access rw;
       reset 16'h0;
    }
  }
  register Seq0BGPR6_p3 @'h300206 {
    field Seq0BGPR6_p3 @0 {
       bits 16;
       access rw;
       reset 16'h0;
    }
  }
  register Seq0BGPR7_p3 @'h300207 {
    field Seq0BGPR7_p3 @0 {
       bits 16;
       access rw;
       reset 16'h0;
    }
  }
  register Seq0BGPR8_p3 @'h300208 {
    field Seq0BGPR8_p3 @0 {
       bits 16;
       access rw;
       reset 16'h0;
    }
  }
}
block dwc_ddrphy_top_DWC_DDRPHYA_MASTER0 {
  endian little;
  bytes 2;
  register RxFifoInit @'h0 {
    field RxFifoInitPtr @0 {
       bits 1;
       access rw;
       reset 1'h0;
    }
    field InhibitRxFifoRd @1 {
       bits 1;
       access rw;
       reset 1'h0;
    }
  }
  register ForceClkDisable @'h1 {
    field ForceClkDisable @0 {
       bits 4;
       access rw;
       reset 4'h0;
    }
  }
  register ClockingCtrl @'h2 {
    field RFU_ClockingCtrl @0 {
       bits 2;
       access rw;
       reset 2'h0;
    }
  }
  register ForceInternalUpdate @'h3 {
    field ForceInternalUpdate @0 {
       bits 1;
       access rw;
       reset 1'h0;
    }
  }
  register PhyConfig @'h4 {
    field PhyConfigAnibs @0 {
       bits 4;
       access ro;
       reset 4'h0;
    }
    field PhyConfigDbytes @4 {
       bits 4;
       access ro;
       reset 4'h0;
    }
    field PhyConfigDfi @8 {
       bits 2;
       access ro;
       reset 2'h0;
    }
  }
  register PGCR @'h5 {
    field RxClkRiseFallMode @0 {
       bits 1;
       access rw;
       reset 1'h0;
    }
  }
  register TestBumpCntrl1 @'h7 {
    field TestMajorMode @0 {
       bits 3;
       access rw;
       reset 3'h3;
    }
    field TestBiasBypassEn @3 {
       bits 1;
       access rw;
       reset 1'h0;
    }
    field TestAnalogOutCtrl @4 {
       bits 4;
       access rw;
       reset 4'h0;
    }
    field TestGainCurrAdj @8 {
       bits 5;
       access rw;
       reset 5'hb;
    }
    field TestSelExternalVref @13 {
       bits 1;
       access rw;
       reset 1'h0;
    }
    field TestExtVrefRange @14 {
       bits 1;
       access rw;
       reset 1'h0;
    }
    field TestPowerGateEn @15 {
       bits 1;
       access rw;
       reset 1'h0;
    }
  }
  register CalUclkInfo_p0 @'h8 {
    field CalUClkTicksPer1uS @0 {
       bits 11;
       access rw;
       reset 11'h320;
    }
  }
  register TestBumpCntrl @'ha {
    field TestBumpEn @0 {
       bits 2;
       access rw;
       reset 2'h0;
    }
    field TestBumpToggle @2 {
       bits 1;
       access rw;
       reset 1'h0;
    }
    field TestBumpDataSel @3 {
       bits 6;
       access rw;
       reset 6'h0;
    }
    field ForceMtestOnAlert @9 {
       bits 1;
       access rw;
       reset 1'h0;
    }
  }
  register Seq0BDLY0_p0 @'hb {
    field Seq0BDLY0_p0 @0 {
       bits 16;
       access rw;
       reset 16'h0;
    }
  }
  register Seq0BDLY1_p0 @'hc {
    field Seq0BDLY1_p0 @0 {
       bits 16;
       access rw;
       reset 16'h0;
    }
  }
  register Seq0BDLY2_p0 @'hd {
    field Seq0BDLY2_p0 @0 {
       bits 16;
       access rw;
       reset 16'h0;
    }
  }
  register Seq0BDLY3_p0 @'he {
    field Seq0BDLY3_p0 @0 {
       bits 16;
       access rw;
       reset 16'h0;
    }
  }
  register PhyAlertStatus @'hf {
    field PhyAlert @0 {
       bits 1;
       access ro;
       reset 1'h0;
    }
  }
  register PPTTrainSetup_p0 @'h10 {
    field PhyMstrTrainInterval @0 {
       bits 4;
       access rw;
       reset 4'h0;
    }
    field PhyMstrMaxReqToAck @4 {
       bits 3;
       access rw;
       reset 3'h0;
    }
  }
  register PPTTrainSetup2_p0 @'h11 {
    field RFU_PPTTrainSetup2_p0 @0 {
       bits 3;
       access rw;
       reset 3'h2;
    }
  }
  register ATestMode @'h12 {
    field ATestPrbsEn @0 {
       bits 1;
       access rw;
       reset 1'h0;
    }
    field ATestClkEn @1 {
       bits 1;
       access rw;
       reset 1'h0;
    }
    field ATestModeSel @2 {
       bits 3;
       access rw;
       reset 3'h0;
    }
  }
  register TxCalBinP @'h14 {
    field TxCalBinP @0 {
       bits 5;
       access ro;
       reset 5'h0;
    }
  }
  register TxCalBinN @'h15 {
    field TxCalBinN @0 {
       bits 5;
       access ro;
       reset 5'h0;
    }
  }
  register TxCalPOvr @'h16 {
    field TxCalBinPOvrVal @0 {
       bits 5;
       access rw;
       reset 5'h0;
    }
    field TxCalBinPOvrEn @5 {
       bits 1;
       access rw;
       reset 1'h0;
    }
  }
  register TxCalNOvr @'h17 {
    field TxCalBinNOvrVal @0 {
       bits 5;
       access rw;
       reset 5'h0;
    }
    field TxCalBinNOvrEn @5 {
       bits 1;
       access rw;
       reset 1'h0;
    }
  }
  register DfiMode @'h18 {
    field Dfi0Enable @0 {
       bits 1;
       access rw;
       reset 1'h1;
    }
    field Dfi1Enable @1 {
       bits 1;
       access rw;
       reset 1'h0;
    }
    field Dfi1Override @2 {
       bits 1;
       access rw;
       reset 1'h1;
    }
  }
  register TristateModeCA_p0 @'h19 {
    field DisDynAdrTri @0 {
       bits 1;
       access rw;
       reset 1'h0;
    }
    field DDR2TMode @1 {
       bits 1;
       access rw;
       reset 1'h0;
    }
    field CkDisVal @2 {
       bits 2;
       access rw;
       reset 2'h0;
    }
  }
  register MtestMuxSel @'h1a {
    field MtestMuxSel @0 {
       bits 6;
       access rw;
       reset 6'h0;
    }
  }
  register MtestPgmInfo @'h1b {
    field MtestPgmInfo @0 {
       bits 1;
       access rw;
       reset 1'h0;
    }
  }
  register DynPwrDnUp @'h1c {
    field DynPowerDown @0 {
       bits 1;
       access rw;
       reset 1'h0;
    }
  }
  register PMIEnable @'h1d {
    field PMIEnable @0 {
       bits 1;
       access rw;
       reset 1'h0;
    }
  }
  register PhyTID @'h1e {
    field PhyTID @0 {
       bits 16;
       access rw;
       reset 16'h0;
    }
  }
  register HwtMRL_p0 @'h20 {
    field HwtMRL_p0 @0 {
       bits 5;
       access rw;
       reset 5'h6;
    }
  }
  register DFIPHYUPD @'h21 {
    field DFIPHYUPDCNT @0 {
       bits 4;
       access rw;
       reset 4'h7;
    }
    field DFIPHYUPDRESP @4 {
       bits 3;
       access rw;
       reset 3'h0;
    }
    field DFIPHYUPDMODE @7 {
       bits 1;
       access rw;
       reset 1'h0;
    }
    field DFIPHYUPDTHRESHOLD @8 {
       bits 4;
       access rw;
       reset 4'hf;
    }
    field DFIPHYUPDINTTHRESHOLD @12 {
       bits 4;
       access rw;
       reset 4'hf;
    }
  }
  register PdaMrsWriteMode @'h22 {
    field PdaMrsWriteMode @0 {
       bits 1;
       access rw;
       reset 1'h0;
    }
  }
  register DFIGEARDOWNCTL @'h23 {
    field DFIGEARDOWNCTL @0 {
       bits 2;
       access rw;
       reset 2'h0;
    }
  }
  register DqsPreambleControl_p0 @'h24 {
    field TwoTckRxDqsPre @0 {
       bits 1;
       access rw;
       reset 1'h0;
    }
    field TwoTckTxDqsPre @1 {
       bits 1;
       access rw;
       reset 1'h0;
    }
    field PositionDfeInit @2 {
       bits 3;
       access rw;
       reset 3'h2;
    }
    field LP4TglTwoTckTxDqsPre @5 {
       bits 1;
       access rw;
       reset 1'h0;
    }
    field LP4PostambleExt @6 {
       bits 1;
       access rw;
       reset 1'h0;
    }
    field LP4SttcPreBridgeRxEn @7 {
       bits 1;
       access rw;
       reset 1'h0;
    }
    field WDQSEXTENSION @8 {
       bits 1;
       access rw;
       reset 1'h0;
    }
  }
  register MasterX4Config @'h25 {
    field X4TG @0 {
       bits 4;
       access rw;
       reset 4'h0;
    }
  }
  register WrLevBits @'h26 {
    field WrLevForDQSL @0 {
       bits 4;
       access rw;
       reset 4'h8;
    }
    field WrLevForDQSU @4 {
       bits 4;
       access rw;
       reset 4'h9;
    }
  }
  register EnableCsMulticast @'h27 {
    field EnableCsMulticast @0 {
       bits 1;
       access rw;
       reset 1'h0;
    }
  }
  register HwtLpCsMultiCast @'h28 {
    field HwtLpCsMultiCast @0 {
       bits 1;
       access rw;
       reset 1'h0;
    }
  }
  register Acx4AnibDis @'h2c {
    field Acx4AnibDis @0 {
       bits 12;
       access rw;
       reset 12'h0;
    }
  }
  register DMIPinPresent_p0 @'h2d {
    field RdDbiEnabled @0 {
       bits 1;
       access rw;
       reset 1'h0;
    }
  }
  register ARdPtrInitVal_p0 @'h2e {
    field ARdPtrInitVal_p0 @0 {
       bits 4;
       access rw;
       reset 4'h0;
    }
  }
  register Db0LcdlCalPhDetOut @'h30 {
    field Db0LcdlCalPhDetOut @0 {
       bits 16;
       access ro;
       reset 16'h0;
    }
  }
  register Db1LcdlCalPhDetOut @'h31 {
    field Db1LcdlCalPhDetOut @0 {
       bits 16;
       access ro;
       reset 16'h0;
    }
  }
  register Db2LcdlCalPhDetOut @'h32 {
    field Db2LcdlCalPhDetOut @0 {
       bits 16;
       access ro;
       reset 16'h0;
    }
  }
  register Db3LcdlCalPhDetOut @'h33 {
    field Db3LcdlCalPhDetOut @0 {
       bits 16;
       access ro;
       reset 16'h0;
    }
  }
  register Db4LcdlCalPhDetOut @'h34 {
    field Db4LcdlCalPhDetOut @0 {
       bits 16;
       access ro;
       reset 16'h0;
    }
  }
  register Db5LcdlCalPhDetOut @'h35 {
    field Db5LcdlCalPhDetOut @0 {
       bits 16;
       access ro;
       reset 16'h0;
    }
  }
  register Db6LcdlCalPhDetOut @'h36 {
    field Db6LcdlCalPhDetOut @0 {
       bits 16;
       access ro;
       reset 16'h0;
    }
  }
  register Db7LcdlCalPhDetOut @'h37 {
    field Db7LcdlCalPhDetOut @0 {
       bits 16;
       access ro;
       reset 16'h0;
    }
  }
  register Db8LcdlCalPhDetOut @'h38 {
    field Db8LcdlCalPhDetOut @0 {
       bits 16;
       access ro;
       reset 16'h0;
    }
  }
  register Db9LcdlCalPhDetOut @'h39 {
    field Db9LcdlCalPhDetOut @0 {
       bits 16;
       access ro;
       reset 16'h0;
    }
  }
  register DbyteDllModeCntrl @'h3a {
    field Reserved @0 {
       bits 1;
    }
    field DllRxPreambleMode @1 {
       bits 1;
       access rw;
       reset 1'h0;
    }
  }
  register DbyteRxEnTrain @'h3b {
    field RFU_DbyteRxEnTrain @0 {
       bits 1;
       access rw;
       reset 1'h0;
    }
  }
  register AnLcdlCalPhDetOut @'h3f {
    field AnLcdlCalPhDetOut @0 {
       bits 12;
       access ro;
       reset 12'h0;
    }
  }
  register CalOffsets @'h45 {
    field CalCmpr5Offset @0 {
       bits 6;
       access rw;
       reset 6'h0;
    }
    field CalDrvPdThOffset @6 {
       bits 4;
       access rw;
       reset 4'h0;
    }
    field CalDrvPuThOffset @10 {
       bits 4;
       access rw;
       reset 4'h0;
    }
  }
  register SarInitVals @'h47 {
    field SarInitOFFSET05 @0 {
       bits 3;
       access rw;
       reset 3'h7;
    }
    field SarInitNINT @3 {
       bits 3;
       access rw;
       reset 3'h4;
    }
    field SarInitPEXT @6 {
       bits 3;
       access rw;
       reset 3'h4;
    }
  }
  register CalPExtOvr @'h49 {
    field CalPExtOvr @0 {
       bits 5;
       access rw;
       reset 5'h0;
    }
  }
  register CalCmpr5Ovr @'h4a {
    field CalCmpr5Ovr @0 {
       bits 8;
       access rw;
       reset 8'h0;
    }
  }
  register CalNIntOvr @'h4b {
    field CalNIntOvr @0 {
       bits 5;
       access rw;
       reset 5'h0;
    }
  }
  register CalDrvStr0 @'h50 {
    field CalDrvStrPd50 @0 {
       bits 4;
       access rw;
       reset 4'h0;
    }
    field CalDrvStrPu50 @4 {
       bits 4;
       access rw;
       reset 4'h0;
    }
  }
  register ProcOdtCtl @'h55 {
    field RFU_ProcOdtCtl @0 {
       bits 2;
       access rw;
       reset 2'h0;
    }
  }
  register ProcOdtTimeCtl_p0 @'h56 {
    field POdtTailWidth @0 {
       bits 2;
       access rw;
       reset 2'h2;
    }
    field POdtStartDelay @2 {
       bits 2;
       access rw;
       reset 2'h1;
    }
    field POdtTailWidthExt @4 {
       bits 2;
       access rw;
       reset 2'h0;
    }
  }
  register MemAlertControl @'h5b {
    field MALERTVrefLevel @0 {
       bits 7;
       access rw;
       reset 7'h0;
    }
    field MALERTVrefExtEn @7 {
       bits 1;
       access rw;
       reset 1'h0;
    }
    field MALERTPuStren @8 {
       bits 4;
       access rw;
       reset 4'h0;
    }
    field MALERTPuEn @12 {
       bits 1;
       access rw;
       reset 1'h0;
    }
    field MALERTRxEn @13 {
       bits 1;
       access rw;
       reset 1'h0;
    }
    field MALERTDisableVal @14 {
       bits 1;
       access rw;
       reset 1'h1;
    }
    field MALERTForceError @15 {
       bits 1;
       access rw;
       reset 1'h0;
    }
  }
  register MemAlertControl2 @'h5c {
    field MALERTSyncBypass @0 {
       bits 1;
       access rw;
       reset 1'h0;
    }
  }
  register MemResetL @'h60 {
    field MemResetLValue @0 {
       bits 1;
       access rw;
       reset 1'h0;
    }
    field ProtectMemReset @1 {
       bits 1;
       access rw;
       reset 1'h0;
    }
  }
  register PUBMODE @'h6e {
    field HwtMemSrc @0 {
       bits 1;
       access rw;
       reset 1'h0;
    }
  }
  register MiscPhyStatus @'h6f {
    field DctSane @0 {
       bits 1;
       access ro;
       reset 1'h0;
    }
    field PORMemReset @1 {
       bits 1;
       access ro;
       reset 1'h0;
    }
  }
  register CoreLoopbackSel @'h70 {
    field CoreLoopbackSel @0 {
       bits 1;
       access rw;
       reset 1'h0;
    }
  }
  register DllTrainParam @'h71 {
    field ExtendPhdTime @0 {
       bits 2;
       access rw;
       reset 2'h2;
    }
  }
  register HwtLpCsEnA @'h72 {
    field HwtLpCsEnA @0 {
       bits 2;
       access rw;
       reset 2'h3;
    }
  }
  register HwtLpCsEnB @'h73 {
    field HwtLpCsEnB @0 {
       bits 2;
       access rw;
       reset 2'h3;
    }
  }
  register HwtLpCsEnBypass @'h74 {
    field HwtLpCsEnBypass @0 {
       bits 1;
       access rw;
       reset 1'h0;
    }
  }
  register DfiCAMode @'h75 {
    field DfiLp3CAMode @0 {
       bits 1;
       access rw;
       reset 1'h0;
    }
    field DfiD4CAMode @1 {
       bits 1;
       access rw;
       reset 1'h0;
    }
    field DfiLp4CAMode @2 {
       bits 1;
       access rw;
       reset 1'h0;
    }
    field DfiD4AltCAMode @3 {
       bits 1;
       access rw;
       reset 1'h0;
    }
  }
  register HwtCACtl @'h76 {
    field RFU_HwtCACtl @0 {
       bits 1;
       access rw;
       reset 1'h1;
    }
  }
  register HwtCAMode @'h77 {
    field RFU_HwtCAMode @0 {
       bits 6;
       access rw;
       reset 6'h0;
    }
  }
  register DllControl @'h78 {
    field DllResetRelock @0 {
       bits 1;
       access rw;
       reset 1'h1;
    }
    field DllResetSlave @1 {
       bits 1;
       access rw;
       reset 1'h1;
    }
    field DllResetRSVD @2 {
       bits 1;
       access rw;
       reset 1'h0;
    }
  }
  register PulseDllUpdatePhase @'h79 {
    field PulseDbyteDllUpdatePhase @0 {
       bits 1;
       access rw;
       reset 1'h0;
    }
    field PulseACkDllUpdatePhase @1 {
       bits 1;
       access rw;
       reset 1'h0;
    }
    field PulseACaDllUpdatePhase @2 {
       bits 1;
       access rw;
       reset 1'h0;
    }
    field UpdatePhaseDestReserved @3 {
       bits 3;
       access rw;
       reset 3'h0;
    }
    field TrainUpdatePhaseOnLongBubble @6 {
       bits 1;
       access rw;
       reset 1'h0;
    }
    field AlwaysUpdateLcdlPhase @7 {
       bits 1;
       access rw;
       reset 1'h0;
    }
  }
  register HwtControlOvr0 @'h7a {
    field RFU_HwtControlOvr0 @0 {
       bits 13;
       access rw;
       reset 13'h0;
    }
  }
  register HwtControlOvr1 @'h7b {
    field RFU_HwtControlOvr1 @0 {
       bits 13;
       access rw;
       reset 13'h0;
    }
  }
  register DllGainCtl_p0 @'h7c {
    field DllGainIV @0 {
       bits 4;
       access rw;
       reset 4'h1;
    }
    field DllGainTV @4 {
       bits 4;
       access rw;
       reset 4'ha;
    }
    field DllSeedSel @8 {
       bits 4;
       access rw;
       reset 4'h0;
    }
  }
  register DllLockParam_p0 @'h7d {
    field RFU_DllLockParam_p0 @0 {
       bits 13;
       access rw;
       reset 13'h17c1;
    }
  }
  register HwtControlVal0 @'h7e {
    field RFU_HwtControlVal0 @0 {
       bits 13;
       access rw;
       reset 13'h0;
    }
  }
  register HwtControlVal1 @'h7f {
    field RFU_HwtControlVal1 @0 {
       bits 13;
       access rw;
       reset 13'h0;
    }
  }
  register AcsmGlblStart @'h81 {
    field AcsmGlblStart @0 {
       bits 1;
       access rw;
       reset 1'h0;
    }
  }
  register AcsmGlblSglStpCtrl @'h82 {
    field RFU_AcsmGlblSglStpCtrl @0 {
       bits 2;
       access rw;
       reset 2'h0;
    }
  }
  register LcdlCalPhase @'h84 {
    field LcdlCalPhase @0 {
       bits 9;
       access rw;
       reset 9'h0;
    }
  }
  register LcdlCalCtrl @'h85 {
    field RFU_LcdlCalCtrl @0 {
       bits 7;
       access rw;
       reset 7'h0;
    }
  }
  register CalRate @'h88 {
    field CalInterval @0 {
       bits 4;
       access rw;
       reset 4'h9;
    }
    field CalRun @4 {
       bits 1;
       access rw;
       reset 1'h0;
    }
    field CalOnce @5 {
       bits 1;
       access rw;
       reset 1'h0;
    }
    field DisableBackgroundZQUpdates @6 {
       bits 1;
       access rw;
       reset 1'h0;
    }
  }
  register CalZap @'h89 {
    field CalZap @0 {
       bits 1;
       access rw;
       reset 1'h0;
    }
  }
  register PState @'h8b {
    field PState @0 {
       bits 4;
       access rw;
       reset 4'hc;
    }
  }
  register CalPreDriverOverride @'h8c {
    field RFU_CalPreDriverOverride @0 {
       bits 8;
       access rw;
       reset 8'h0;
    }
  }
  register PllOutGateControl @'h8d {
    field PclkGateEn @0 {
       bits 1;
       access rw;
       reset 1'h0;
    }
    field Reserved2x1 @1 {
       bits 1;
       access rw;
       reset 1'h0;
    }
  }
  register UcMemResetControl @'h8f {
    field RFU_UcMemResetControl @0 {
       bits 1;
       access rw;
       reset 1'h0;
    }
  }
  register PorControl @'h90 {
    field PllDllLockDone @0 {
       bits 1;
       access rw;
       reset 1'h0;
    }
  }
  register CalBusy @'h97 {
    field CalBusy @0 {
       bits 1;
       access ro;
       reset 1'h0;
    }
  }
  register CalMisc2 @'h98 {
    field CalNumVotes @0 {
       bits 3;
       access rw;
       reset 3'h4;
    }
    field Reserved10x3 @3 {
       bits 8;
       access rw;
       reset 8'h0;
    }
    field Reserved11 @11 {
       bits 1;
       access rw;
       reset 1'h0;
    }
    field CalCmptrResTrim @12 {
       bits 1;
       access rw;
       reset 1'h0;
    }
    field CalCancelRoundErrDis @13 {
       bits 1;
       access rw;
       reset 1'h0;
    }
    field CalSlowCmpana @14 {
       bits 1;
       access rw;
       reset 1'h0;
    }
    field Reserved15 @15 {
       bits 1;
       access rw;
       reset 1'h0;
    }
  }
  register CalMisc @'h9a {
    field CalCmpr5Dis @0 {
       bits 1;
       access rw;
       reset 1'h0;
    }
    field CalNIntDis @1 {
       bits 1;
       access rw;
       reset 1'h0;
    }
    field CalPExtDis @2 {
       bits 1;
       access rw;
       reset 1'h0;
    }
  }
  register CalVRefs @'h9b {
    field CalVRefs @0 {
       bits 2;
       access rw;
       reset 2'h2;
    }
  }
  register CalCmpr5 @'h9c {
    field CalCmpr5 @0 {
       bits 8;
       access ro;
       reset 8'h0;
    }
  }
  register CalNInt @'h9d {
    field CalNIntThB @0 {
       bits 5;
       access ro;
       reset 5'h0;
    }
  }
  register CalPExt @'h9e {
    field CalPExtThB @0 {
       bits 5;
       access ro;
       reset 5'h0;
    }
  }
  register CalCmpInvert @'ha8 {
    field CmpInvertCalDac50 @0 {
       bits 1;
       access rw;
       reset 1'h1;
    }
    field CmpInvertCalDrvPd50 @1 {
       bits 1;
       access rw;
       reset 1'h1;
    }
    field CmpInvertCalDrvPu50 @2 {
       bits 1;
       access rw;
       reset 1'h0;
    }
    field CmpInvertCalOdtPd @3 {
       bits 1;
       access rw;
       reset 1'h0;
    }
    field CmpInvertCalOdtPu @4 {
       bits 1;
       access rw;
       reset 1'h0;
    }
  }
  register CalCmpanaCntrl @'hae {
    field CmprGainCurrAdj @0 {
       bits 8;
       access rw;
       reset 8'h12;
    }
    field CmprGainResAdj @8 {
       bits 1;
       access rw;
       reset 1'h1;
    }
    field CmprBiasBypassEn @9 {
       bits 1;
       access rw;
       reset 1'h0;
    }
  }
  register DfiRdDataCsDestMap_p0 @'hb0 {
    field DfiRdDestm0 @0 {
       bits 2;
       access rw;
       reset 2'h0;
    }
    field DfiRdDestm1 @2 {
       bits 2;
       access rw;
       reset 2'h1;
    }
    field DfiRdDestm2 @4 {
       bits 2;
       access rw;
       reset 2'h2;
    }
    field DfiRdDestm3 @6 {
       bits 2;
       access rw;
       reset 2'h3;
    }
  }
  register VrefInGlobal_p0 @'hb2 {
    field GlobalVrefInSel @0 {
       bits 3;
       access rw;
       reset 3'h0;
    }
    field GlobalVrefInDAC @3 {
       bits 7;
       access rw;
       reset 7'h40;
    }
    field GlobalVrefInTrim @10 {
       bits 4;
       access rw;
       reset 4'h0;
    }
    field GlobalVrefInMode @14 {
       bits 1;
       access rw;
       reset 1'h0;
    }
  }
  register DfiWrDataCsDestMap_p0 @'hb4 {
    field DfiWrDestm0 @0 {
       bits 2;
       access rw;
       reset 2'h0;
    }
    field DfiWrDestm1 @2 {
       bits 2;
       access rw;
       reset 2'h1;
    }
    field DfiWrDestm2 @4 {
       bits 2;
       access rw;
       reset 2'h2;
    }
    field DfiWrDestm3 @6 {
       bits 2;
       access rw;
       reset 2'h3;
    }
  }
  register MasUpdGoodCtr @'hb5 {
    field MasUpdGoodCtr @0 {
       bits 16;
       access ro;
       reset 16'h0;
    }
  }
  register PhyUpd0GoodCtr @'hb6 {
    field PhyUpd0GoodCtr @0 {
       bits 16;
       access ro;
       reset 16'h0;
    }
  }
  register PhyUpd1GoodCtr @'hb7 {
    field PhyUpd1GoodCtr @0 {
       bits 16;
       access ro;
       reset 16'h0;
    }
  }
  register CtlUpd0GoodCtr @'hb8 {
    field CtlUpd0GoodCtr @0 {
       bits 16;
       access ro;
       reset 16'h0;
    }
  }
  register CtlUpd1GoodCtr @'hb9 {
    field CtlUpd1GoodCtr @0 {
       bits 16;
       access ro;
       reset 16'h0;
    }
  }
  register MasUpdFailCtr @'hba {
    field MasUpdFailCtr @0 {
       bits 16;
       access ro;
       reset 16'h0;
    }
  }
  register PhyUpd0FailCtr @'hbb {
    field PhyUpd0FailCtr @0 {
       bits 16;
       access ro;
       reset 16'h0;
    }
  }
  register PhyUpd1FailCtr @'hbc {
    field PhyUpd1FailCtr @0 {
       bits 16;
       access ro;
       reset 16'h0;
    }
  }
  register PhyPerfCtrEnable @'hbd {
    field MasUpdGoodCtl @0 {
       bits 1;
       access rw;
       reset 1'h0;
    }
    field PhyUpd0GoodCtl @1 {
       bits 1;
       access rw;
       reset 1'h0;
    }
    field PhyUpd1GoodCtl @2 {
       bits 1;
       access rw;
       reset 1'h0;
    }
    field CtlUpd0GoodCtl @3 {
       bits 1;
       access rw;
       reset 1'h0;
    }
    field CtlUpd1GoodCtl @4 {
       bits 1;
       access rw;
       reset 1'h0;
    }
    field MasUpdFailCtl @5 {
       bits 1;
       access rw;
       reset 1'h0;
    }
    field PhyUpd0FailCtl @6 {
       bits 1;
       access rw;
       reset 1'h0;
    }
    field PhyUpd1FailCtl @7 {
       bits 1;
       access rw;
       reset 1'h0;
    }
  }
  register PllPwrDn @'hc3 {
    field PllPwrDn @0 {
       bits 1;
       access rw;
       reset 1'h1;
    }
  }
  register PllReset @'hc4 {
    field PllReset @0 {
       bits 1;
       access rw;
       reset 1'h1;
    }
  }
  register PllCtrl2_p0 @'hc5 {
    field PllFreqSel @0 {
       bits 5;
       access rw;
       reset 5'h19;
    }
  }
  register PllCtrl0 @'hc6 {
    field PllStandby @0 {
       bits 1;
       access rw;
       reset 1'h0;
    }
    field PllBypSel @1 {
       bits 1;
       access rw;
       reset 1'h0;
    }
    field PllX2Mode @2 {
       bits 1;
       access rw;
       reset 1'h0;
    }
    field PllOutBypEn @3 {
       bits 1;
       access rw;
       reset 1'h1;
    }
    field PllPreset @4 {
       bits 1;
       access rw;
       reset 1'h0;
    }
    field PllBypassMode @5 {
       bits 1;
       access rw;
       reset 1'h0;
    }
    field PllSelDfiFreqRatio @6 {
       bits 1;
       access rw;
       reset 1'h0;
    }
    field PllSyncBusFlush @7 {
       bits 1;
       access rw;
       reset 1'h0;
    }
    field PllSyncBusByp @8 {
       bits 1;
       access rw;
       reset 1'h0;
    }
    field PllReserved10x9 @9 {
       bits 2;
       access rw;
       reset 2'h0;
    }
    field PllGearShift @11 {
       bits 1;
       access rw;
       reset 1'h0;
    }
    field PllLockCntSel @12 {
       bits 1;
       access rw;
       reset 1'h0;
    }
    field PllLockPhSel @13 {
       bits 2;
       access rw;
       reset 2'h1;
    }
    field PllSpareCtrl0 @15 {
       bits 1;
       access rw;
       reset 1'h0;
    }
  }
  register PllCtrl1_p0 @'hc7 {
    field PllCpIntCtrl @0 {
       bits 5;
       access rw;
       reset 5'h0;
    }
    field PllCpPropCtrl @5 {
       bits 4;
       access rw;
       reset 4'h1;
    }
  }
  register PllTst @'hc8 {
    field PllAnaTstEn @0 {
       bits 1;
       access rw;
       reset 1'h0;
    }
    field PllAnaTstSel @1 {
       bits 4;
       access rw;
       reset 4'h0;
    }
    field PllDigTstSel @5 {
       bits 4;
       access rw;
       reset 4'h0;
    }
  }
  register PllLockStatus @'hc9 {
    field PllLockStatus @0 {
       bits 1;
       access ro;
       reset 1'h0;
    }
  }
  register PllTestMode_p0 @'hca {
    field PllTestMode_p0 @0 {
       bits 16;
       access rw;
       reset 16'h124;
    }
  }
  register PllCtrl3 @'hcb {
    field PllSpare @0 {
       bits 4;
       access rw;
       reset 4'h0;
    }
    field PllMaxRange @4 {
       bits 5;
       access rw;
       reset 5'h1f;
    }
    field PllDacValIn @9 {
       bits 5;
       access rw;
       reset 5'h0;
    }
    field PllForceCal @14 {
       bits 1;
       access rw;
       reset 1'h0;
    }
    field PllEnCal @15 {
       bits 1;
       access rw;
       reset 1'h0;
    }
  }
  register PllCtrl4_p0 @'hcc {
    field PllCpIntGsCtrl @0 {
       bits 5;
       access rw;
       reset 5'h1f;
    }
    field PllCpPropGsCtrl @5 {
       bits 4;
       access rw;
       reset 4'hb;
    }
  }
  register PllEndofCal @'hcd {
    field PllEndofCal @0 {
       bits 1;
       access ro;
       reset 1'h0;
    }
  }
  register PllStandbyEff @'hce {
    field PllStandbyEff @0 {
       bits 1;
       access ro;
       reset 1'h0;
    }
  }
  register PllDacValOut @'hcf {
    field PllDacValOut @0 {
       bits 5;
       access ro;
       reset 5'h0;
    }
  }
  register DlyTestSeq @'hd0 {
    field RFU_DlyTestSeq @0 {
       bits 6;
       access rw;
       reset 6'h0;
    }
  }
  register DlyTestRingSelDb @'hd1 {
    field RFU_DlyTestRingSelDb @0 {
       bits 5;
       access rw;
       reset 5'h0;
    }
  }
  register DlyTestRingSelAc @'hd2 {
    field RFU_DlyTestRingSelAc @0 {
       bits 5;
       access rw;
       reset 5'h0;
    }
  }
  register DlyTestCntDfiClkIV @'hd3 {
    field DlyTestCntDfiClkIV @0 {
       bits 16;
       access rw;
       reset 16'h0;
    }
  }
  register DlyTestCntDfiClk @'hd4 {
    field DlyTestCntDfiClk @0 {
       bits 16;
       access ro;
       reset 16'h0;
    }
  }
  register DlyTestCntRingOscDb0 @'hd5 {
    field DlyTestCntRingOscDb0 @0 {
       bits 16;
       access ro;
       reset 16'h0;
    }
  }
  register DlyTestCntRingOscDb1 @'hd6 {
    field DlyTestCntRingOscDb1 @0 {
       bits 16;
       access ro;
       reset 16'h0;
    }
  }
  register DlyTestCntRingOscDb2 @'hd7 {
    field DlyTestCntRingOscDb2 @0 {
       bits 16;
       access ro;
       reset 16'h0;
    }
  }
  register DlyTestCntRingOscDb3 @'hd8 {
    field DlyTestCntRingOscDb3 @0 {
       bits 16;
       access ro;
       reset 16'h0;
    }
  }
  register DlyTestCntRingOscDb4 @'hd9 {
    field DlyTestCntRingOscDb4 @0 {
       bits 16;
       access ro;
       reset 16'h0;
    }
  }
  register DlyTestCntRingOscDb5 @'hda {
    field DlyTestCntRingOscDb5 @0 {
       bits 16;
       access ro;
       reset 16'h0;
    }
  }
  register DlyTestCntRingOscDb6 @'hdb {
    field DlyTestCntRingOscDb6 @0 {
       bits 16;
       access ro;
       reset 16'h0;
    }
  }
  register DlyTestCntRingOscDb7 @'hdc {
    field DlyTestCntRingOscDb7 @0 {
       bits 16;
       access ro;
       reset 16'h0;
    }
  }
  register DlyTestCntRingOscDb8 @'hdd {
    field DlyTestCntRingOscDb8 @0 {
       bits 16;
       access ro;
       reset 16'h0;
    }
  }
  register DlyTestCntRingOscDb9 @'hde {
    field DlyTestCntRingOscDb9 @0 {
       bits 16;
       access ro;
       reset 16'h0;
    }
  }
  register DlyTestCntRingOscAc @'hdf {
    field DlyTestCntRingOscAc @0 {
       bits 16;
       access ro;
       reset 16'h0;
    }
  }
  register MstLcdlDbgCntl @'he0 {
    field RFU_MstLcdlDbgCntl @0 {
       bits 12;
       access rw;
       reset 12'h0;
    }
  }
  register MstLcdl0DbgRes @'he1 {
    field RFU_MstLcdl0DbgRes @0 {
       bits 13;
       access ro;
       reset 13'h0;
    }
  }
  register MstLcdl1DbgRes @'he2 {
    field RFU_MstLcdl1DbgRes @0 {
       bits 13;
       access ro;
       reset 13'h0;
    }
  }
  register LcdlDbgCntl @'he3 {
    field LcdlFineOvrVal @0 {
       bits 9;
       access rw;
       reset 9'h0;
    }
    field LcdlFineOvr @9 {
       bits 1;
       access rw;
       reset 1'h0;
    }
    field LcdlFineSnap @10 {
       bits 1;
       access rw;
       reset 1'h0;
    }
    field LcdlTstEnable @11 {
       bits 1;
       access rw;
       reset 1'h0;
    }
    field LcdlStatusSel @12 {
       bits 4;
       access rw;
       reset 4'h0;
    }
  }
  register AcLcdlStatus @'he4 {
    field AcLcdlFineSnapVal @0 {
       bits 10;
       access ro;
       reset 10'h0;
    }
    field AcLcdlPhdSnapVal @10 {
       bits 1;
       access ro;
       reset 1'h0;
    }
    field AcLcdlStickyLock @11 {
       bits 1;
       access ro;
       reset 1'h0;
    }
    field AcLcdlStickyUnlock @12 {
       bits 1;
       access ro;
       reset 1'h0;
    }
    field AcLcdlLiveLock @13 {
       bits 1;
       access ro;
       reset 1'h0;
    }
  }
  register CUSTPHYREV @'hed {
    field CUSTPHYREV @0 {
       bits 6;
       access ro;
       reset 6'h0;
    }
  }
  register PHYREV @'hee {
    field PHYMNR @0 {
       bits 4;
       access ro;
       reset 4'h0;
    }
    field PHYMDR @4 {
       bits 4;
       access ro;
       reset 4'h0;
    }
    field PHYMJR @8 {
       bits 8;
       access ro;
       reset 8'h1;
    }
  }
  register LP3ExitSeq0BStartVector @'hef {
    field LP3ExitSeq0BStartVecPllEnabled @0 {
       bits 4;
       access rw;
       reset 4'he;
    }
    field LP3ExitSeq0BStartVecPllBypassed @4 {
       bits 4;
       access rw;
       reset 4'hd;
    }
  }
  register DfiFreqXlat0 @'hf0 {
    field DfiFreqXlatVal0 @0 {
       bits 4;
       access rw;
       reset 4'h0;
    }
    field DfiFreqXlatVal1 @4 {
       bits 4;
       access rw;
       reset 4'h0;
    }
    field DfiFreqXlatVal2 @8 {
       bits 4;
       access rw;
       reset 4'h0;
    }
    field DfiFreqXlatVal3 @12 {
       bits 4;
       access rw;
       reset 4'h0;
    }
  }
  register DfiFreqXlat1 @'hf1 {
    field DfiFreqXlatVal4 @0 {
       bits 4;
       access rw;
       reset 4'h0;
    }
    field DfiFreqXlatVal5 @4 {
       bits 4;
       access rw;
       reset 4'h0;
    }
    field DfiFreqXlatVal6 @8 {
       bits 4;
       access rw;
       reset 4'h0;
    }
    field DfiFreqXlatVal7 @12 {
       bits 4;
       access rw;
       reset 4'h0;
    }
  }
  register DfiFreqXlat2 @'hf2 {
    field DfiFreqXlatVal8 @0 {
       bits 4;
       access rw;
       reset 4'h0;
    }
    field DfiFreqXlatVal9 @4 {
       bits 4;
       access rw;
       reset 4'h0;
    }
    field DfiFreqXlatVal10 @8 {
       bits 4;
       access rw;
       reset 4'h0;
    }
    field DfiFreqXlatVal11 @12 {
       bits 4;
       access rw;
       reset 4'h0;
    }
  }
  register DfiFreqXlat3 @'hf3 {
    field DfiFreqXlatVal12 @0 {
       bits 4;
       access rw;
       reset 4'h0;
    }
    field DfiFreqXlatVal13 @4 {
       bits 4;
       access rw;
       reset 4'h0;
    }
    field DfiFreqXlatVal14 @8 {
       bits 4;
       access rw;
       reset 4'h0;
    }
    field DfiFreqXlatVal15 @12 {
       bits 4;
       access rw;
       reset 4'h0;
    }
  }
  register DfiFreqXlat4 @'hf4 {
    field DfiFreqXlatVal16 @0 {
       bits 4;
       access rw;
       reset 4'h0;
    }
    field DfiFreqXlatVal17 @4 {
       bits 4;
       access rw;
       reset 4'h0;
    }
    field DfiFreqXlatVal18 @8 {
       bits 4;
       access rw;
       reset 4'h0;
    }
    field DfiFreqXlatVal19 @12 {
       bits 4;
       access rw;
       reset 4'h0;
    }
  }
  register DfiFreqXlat5 @'hf5 {
    field DfiFreqXlatVal20 @0 {
       bits 4;
       access rw;
       reset 4'h0;
    }
    field DfiFreqXlatVal21 @4 {
       bits 4;
       access rw;
       reset 4'h0;
    }
    field DfiFreqXlatVal22 @8 {
       bits 4;
       access rw;
       reset 4'h0;
    }
    field DfiFreqXlatVal23 @12 {
       bits 4;
       access rw;
       reset 4'h0;
    }
  }
  register DfiFreqXlat6 @'hf6 {
    field DfiFreqXlatVal24 @0 {
       bits 4;
       access rw;
       reset 4'h0;
    }
    field DfiFreqXlatVal25 @4 {
       bits 4;
       access rw;
       reset 4'h0;
    }
    field DfiFreqXlatVal26 @8 {
       bits 4;
       access rw;
       reset 4'h0;
    }
    field DfiFreqXlatVal27 @12 {
       bits 4;
       access rw;
       reset 4'h0;
    }
  }
  register DfiFreqXlat7 @'hf7 {
    field DfiFreqXlatVal28 @0 {
       bits 4;
       access rw;
       reset 4'h0;
    }
    field DfiFreqXlatVal29 @4 {
       bits 4;
       access rw;
       reset 4'h0;
    }
    field DfiFreqXlatVal30 @8 {
       bits 4;
       access rw;
       reset 4'h0;
    }
    field DfiFreqXlatVal31 @12 {
       bits 4;
       access rw;
       reset 4'h0;
    }
  }
  register TxRdPtrInit @'hf8 {
    field TxRdPtrInit @0 {
       bits 1;
       access rw;
       reset 1'h1;
    }
  }
  register DfiInitComplete @'hf9 {
    field DfiInitComplete @0 {
       bits 1;
       access rw;
       reset 1'h0;
    }
  }
  register DfiFreqRatio_p0 @'hfa {
    field DfiFreqRatio_p0 @0 {
       bits 2;
       access rw;
       reset 2'h1;
    }
  }
  register RxFifoChecks @'hfb {
    field DoFrequentRxFifoChecks @0 {
       bits 1;
       access rw;
       reset 1'h0;
    }
  }
  register MTestDtoCtrl @'hff {
    field MTESTdtoEn @0 {
       bits 1;
       access rw;
       reset 1'h0;
    }
  }
  register MapCAA0toDfi @'h100 {
    field MapCAA0toDfi @0 {
       bits 4;
       access rw;
       reset 4'h0;
    }
  }
  register MapCAA1toDfi @'h101 {
    field MapCAA1toDfi @0 {
       bits 4;
       access rw;
       reset 4'h1;
    }
  }
  register MapCAA2toDfi @'h102 {
    field MapCAA2toDfi @0 {
       bits 4;
       access rw;
       reset 4'h2;
    }
  }
  register MapCAA3toDfi @'h103 {
    field MapCAA3toDfi @0 {
       bits 4;
       access rw;
       reset 4'h3;
    }
  }
  register MapCAA4toDfi @'h104 {
    field MapCAA4toDfi @0 {
       bits 4;
       access rw;
       reset 4'h4;
    }
  }
  register MapCAA5toDfi @'h105 {
    field MapCAA5toDfi @0 {
       bits 4;
       access rw;
       reset 4'h5;
    }
  }
  register MapCAA6toDfi @'h106 {
    field MapCAA6toDfi @0 {
       bits 4;
       access rw;
       reset 4'h6;
    }
  }
  register MapCAA7toDfi @'h107 {
    field MapCAA7toDfi @0 {
       bits 4;
       access rw;
       reset 4'h7;
    }
  }
  register MapCAA8toDfi @'h108 {
    field MapCAA8toDfi @0 {
       bits 4;
       access rw;
       reset 4'h8;
    }
  }
  register MapCAA9toDfi @'h109 {
    field MapCAA9toDfi @0 {
       bits 4;
       access rw;
       reset 4'h9;
    }
  }
  register MapCAB0toDfi @'h110 {
    field MapCAB0toDfi @0 {
       bits 4;
       access rw;
       reset 4'h0;
    }
  }
  register MapCAB1toDfi @'h111 {
    field MapCAB1toDfi @0 {
       bits 4;
       access rw;
       reset 4'h1;
    }
  }
  register MapCAB2toDfi @'h112 {
    field MapCAB2toDfi @0 {
       bits 4;
       access rw;
       reset 4'h2;
    }
  }
  register MapCAB3toDfi @'h113 {
    field MapCAB3toDfi @0 {
       bits 4;
       access rw;
       reset 4'h3;
    }
  }
  register MapCAB4toDfi @'h114 {
    field MapCAB4toDfi @0 {
       bits 4;
       access rw;
       reset 4'h4;
    }
  }
  register MapCAB5toDfi @'h115 {
    field MapCAB5toDfi @0 {
       bits 4;
       access rw;
       reset 4'h5;
    }
  }
  register MapCAB6toDfi @'h116 {
    field MapCAB6toDfi @0 {
       bits 4;
       access rw;
       reset 4'h6;
    }
  }
  register MapCAB7toDfi @'h117 {
    field MapCAB7toDfi @0 {
       bits 4;
       access rw;
       reset 4'h7;
    }
  }
  register MapCAB8toDfi @'h118 {
    field MapCAB8toDfi @0 {
       bits 4;
       access rw;
       reset 4'h8;
    }
  }
  register MapCAB9toDfi @'h119 {
    field MapCAB9toDfi @0 {
       bits 4;
       access rw;
       reset 4'h9;
    }
  }
  register PhyInterruptEnable @'h11b {
    field PhyTrngCmpltEn @0 {
       bits 1;
       access rw;
       reset 1'h0;
    }
    field PhyInitCmpltEn @1 {
       bits 1;
       access rw;
       reset 1'h0;
    }
    field PhyTrngFailEn @2 {
       bits 1;
       access rw;
       reset 1'h0;
    }
    field PhyFWReservedEn @3 {
       bits 5;
       access rw;
       reset 5'h0;
    }
    field PhyVTDriftAlarmEn @8 {
       bits 2;
       access rw;
       reset 2'h0;
    }
    field PhyRxFifoCheckEn @10 {
       bits 1;
       access rw;
       reset 1'h0;
    }
    field PhyHWReservedEn @11 {
       bits 5;
       access rw;
       reset 5'h0;
    }
  }
  register PhyInterruptFWControl @'h11c {
    field PhyTrngCmpltFW @0 {
       bits 1;
       access rw;
       reset 1'h0;
    }
    field PhyInitCmpltFW @1 {
       bits 1;
       access rw;
       reset 1'h0;
    }
    field PhyTrngFailFW @2 {
       bits 1;
       access rw;
       reset 1'h0;
    }
    field PhyFWReservedFW @3 {
       bits 5;
       access rw;
       reset 5'h0;
    }
  }
  register PhyInterruptMask @'h11d {
    field PhyTrngCmpltMsk @0 {
       bits 1;
       access rw;
       reset 1'h0;
    }
    field PhyInitCmpltMsk @1 {
       bits 1;
       access rw;
       reset 1'h0;
    }
    field PhyTrngFailMsk @2 {
       bits 1;
       access rw;
       reset 1'h0;
    }
    field PhyFWReservedMsk @3 {
       bits 5;
       access rw;
       reset 5'h0;
    }
    field PhyVTDriftAlarmMsk @8 {
       bits 2;
       access rw;
       reset 2'h0;
    }
    field PhyRxFifoCheckMsk @10 {
       bits 1;
       access rw;
       reset 1'h0;
    }
    field PhyHWReservedMsk @11 {
       bits 5;
       access rw;
       reset 5'h0;
    }
  }
  register PhyInterruptClear @'h11e {
    field PhyTrngCmpltClr @0 {
       bits 1;
       access rw;
       reset 1'h0;
    }
    field PhyInitCmpltClr @1 {
       bits 1;
       access rw;
       reset 1'h0;
    }
    field PhyTrngFailClr @2 {
       bits 1;
       access rw;
       reset 1'h0;
    }
    field PhyFWReservedClr @3 {
       bits 5;
       access rw;
       reset 5'h0;
    }
    field PhyVTDriftAlarmClr @8 {
       bits 2;
       access rw;
       reset 2'h0;
    }
    field PhyRxFifoCheckClr @10 {
       bits 1;
       access rw;
       reset 1'h0;
    }
    field PhyHWReservedClr @11 {
       bits 5;
       access rw;
       reset 5'h0;
    }
  }
  register PhyInterruptStatus @'h11f {
    field PhyTrngCmplt @0 {
       bits 1;
       access ro;
       reset 1'h0;
    }
    field PhyInitCmplt @1 {
       bits 1;
       access ro;
       reset 1'h0;
    }
    field PhyTrngFail @2 {
       bits 1;
       access ro;
       reset 1'h0;
    }
    field PhyFWReserved @3 {
       bits 5;
       access ro;
       reset 5'h0;
    }
    field VTDriftAlarm @8 {
       bits 2;
       access ro;
       reset 2'h0;
    }
    field PhyRxFifoCheck @10 {
       bits 1;
       access ro;
       reset 1'h0;
    }
    field PhyHWReserved @11 {
       bits 5;
       access ro;
       reset 5'h0;
    }
  }
  register HwtSwizzleHwtAddress0 @'h120 {
    field HwtSwizzleHwtAddress0 @0 {
       bits 5;
       access rw;
       reset 5'h0;
    }
  }
  register HwtSwizzleHwtAddress1 @'h121 {
    field HwtSwizzleHwtAddress1 @0 {
       bits 5;
       access rw;
       reset 5'h0;
    }
  }
  register HwtSwizzleHwtAddress2 @'h122 {
    field HwtSwizzleHwtAddress2 @0 {
       bits 5;
       access rw;
       reset 5'h0;
    }
  }
  register HwtSwizzleHwtAddress3 @'h123 {
    field HwtSwizzleHwtAddress3 @0 {
       bits 5;
       access rw;
       reset 5'h0;
    }
  }
  register HwtSwizzleHwtAddress4 @'h124 {
    field HwtSwizzleHwtAddress4 @0 {
       bits 5;
       access rw;
       reset 5'h0;
    }
  }
  register HwtSwizzleHwtAddress5 @'h125 {
    field HwtSwizzleHwtAddress5 @0 {
       bits 5;
       access rw;
       reset 5'h0;
    }
  }
  register HwtSwizzleHwtAddress6 @'h126 {
    field HwtSwizzleHwtAddress6 @0 {
       bits 5;
       access rw;
       reset 5'h0;
    }
  }
  register HwtSwizzleHwtAddress7 @'h127 {
    field HwtSwizzleHwtAddress7 @0 {
       bits 5;
       access rw;
       reset 5'h0;
    }
  }
  register HwtSwizzleHwtAddress8 @'h128 {
    field HwtSwizzleHwtAddress8 @0 {
       bits 5;
       access rw;
       reset 5'h0;
    }
  }
  register HwtSwizzleHwtAddress9 @'h129 {
    field HwtSwizzleHwtAddress9 @0 {
       bits 5;
       access rw;
       reset 5'h0;
    }
  }
  register HwtSwizzleHwtAddress10 @'h12a {
    field HwtSwizzleHwtAddress10 @0 {
       bits 5;
       access rw;
       reset 5'h0;
    }
  }
  register HwtSwizzleHwtAddress11 @'h12b {
    field HwtSwizzleHwtAddress11 @0 {
       bits 5;
       access rw;
       reset 5'h0;
    }
  }
  register HwtSwizzleHwtAddress12 @'h12c {
    field HwtSwizzleHwtAddress12 @0 {
       bits 5;
       access rw;
       reset 5'h0;
    }
  }
  register HwtSwizzleHwtAddress13 @'h12d {
    field HwtSwizzleHwtAddress13 @0 {
       bits 5;
       access rw;
       reset 5'h0;
    }
  }
  register HwtSwizzleHwtAddress14 @'h12e {
    field HwtSwizzleHwtAddress14 @0 {
       bits 5;
       access rw;
       reset 5'h0;
    }
  }
  register HwtSwizzleHwtAddress15 @'h12f {
    field HwtSwizzleHwtAddress15 @0 {
       bits 5;
       access rw;
       reset 5'h0;
    }
  }
  register HwtSwizzleHwtAddress17 @'h130 {
    field HwtSwizzleHwtAddress17 @0 {
       bits 5;
       access rw;
       reset 5'h0;
    }
  }
  register HwtSwizzleHwtActN @'h131 {
    field HwtSwizzleHwtActN @0 {
       bits 5;
       access rw;
       reset 5'h0;
    }
  }
  register HwtSwizzleHwtBank0 @'h132 {
    field HwtSwizzleHwtBank0 @0 {
       bits 5;
       access rw;
       reset 5'h0;
    }
  }
  register HwtSwizzleHwtBank1 @'h133 {
    field HwtSwizzleHwtBank1 @0 {
       bits 5;
       access rw;
       reset 5'h0;
    }
  }
  register HwtSwizzleHwtBank2 @'h134 {
    field HwtSwizzleHwtBank2 @0 {
       bits 5;
       access rw;
       reset 5'h0;
    }
  }
  register HwtSwizzleHwtBg0 @'h135 {
    field HwtSwizzleHwtBg0 @0 {
       bits 5;
       access rw;
       reset 5'h0;
    }
  }
  register HwtSwizzleHwtBg1 @'h136 {
    field HwtSwizzleHwtBg1 @0 {
       bits 5;
       access rw;
       reset 5'h0;
    }
  }
  register HwtSwizzleHwtCasN @'h137 {
    field HwtSwizzleHwtCasN @0 {
       bits 5;
       access rw;
       reset 5'h0;
    }
  }
  register HwtSwizzleHwtRasN @'h138 {
    field HwtSwizzleHwtRasN @0 {
       bits 5;
       access rw;
       reset 5'h0;
    }
  }
  register HwtSwizzleHwtWeN @'h139 {
    field HwtSwizzleHwtWeN @0 {
       bits 5;
       access rw;
       reset 5'h0;
    }
  }
  register HwtSwizzleHwtParityIn @'h13a {
    field HwtSwizzleHwtParityIn @0 {
       bits 5;
       access rw;
       reset 5'h0;
    }
  }
  register DfiHandshakeDelays0 @'h13c {
    field PhyUpdAckDelay0 @0 {
       bits 4;
       access rw;
       reset 4'h0;
    }
    field PhyUpdReqDelay0 @4 {
       bits 4;
       access rw;
       reset 4'h0;
    }
    field CtrlUpdAckDelay0 @8 {
       bits 4;
       access rw;
       reset 4'h0;
    }
    field CtrlUpdReqDelay0 @12 {
       bits 4;
       access rw;
       reset 4'h0;
    }
  }
  register DfiHandshakeDelays1 @'h13d {
    field PhyUpdAckDelay1 @0 {
       bits 4;
       access rw;
       reset 4'h0;
    }
    field PhyUpdReqDelay1 @4 {
       bits 4;
       access rw;
       reset 4'h0;
    }
    field CtrlUpdAckDelay1 @8 {
       bits 4;
       access rw;
       reset 4'h0;
    }
    field CtrlUpdReqDelay1 @12 {
       bits 4;
       access rw;
       reset 4'h0;
    }
  }
  register RemoteImpCal @'h13e {
    field CalibSlave @0 {
       bits 1;
       access ro;
       reset 1'h0;
    }
    field SlaveCodeUpdated @1 {
       bits 1;
       access ro;
       reset 1'h0;
    }
  }
  register ACLoopbackCtl @'h13f {
    field RFU_ACLoopbackCtl @0 {
       bits 2;
       access rw;
       reset 2'h0;
    }
  }
  register CalUclkInfo_p1 @'h100008 {
    field CalUClkTicksPer1uS @0 {
       bits 11;
       access rw;
       reset 11'h320;
    }
  }
  register Seq0BDLY0_p1 @'h10000b {
    field Seq0BDLY0_p1 @0 {
       bits 16;
       access rw;
       reset 16'h0;
    }
  }
  register Seq0BDLY1_p1 @'h10000c {
    field Seq0BDLY1_p1 @0 {
       bits 16;
       access rw;
       reset 16'h0;
    }
  }
  register Seq0BDLY2_p1 @'h10000d {
    field Seq0BDLY2_p1 @0 {
       bits 16;
       access rw;
       reset 16'h0;
    }
  }
  register Seq0BDLY3_p1 @'h10000e {
    field Seq0BDLY3_p1 @0 {
       bits 16;
       access rw;
       reset 16'h0;
    }
  }
  register PPTTrainSetup_p1 @'h100010 {
    field PhyMstrTrainInterval @0 {
       bits 4;
       access rw;
       reset 4'h0;
    }
    field PhyMstrMaxReqToAck @4 {
       bits 3;
       access rw;
       reset 3'h0;
    }
  }
  register PPTTrainSetup2_p1 @'h100011 {
    field RFU_PPTTrainSetup2_p1 @0 {
       bits 3;
       access rw;
       reset 3'h2;
    }
  }
  register TristateModeCA_p1 @'h100019 {
    field DisDynAdrTri @0 {
       bits 1;
       access rw;
       reset 1'h0;
    }
    field DDR2TMode @1 {
       bits 1;
       access rw;
       reset 1'h0;
    }
    field CkDisVal @2 {
       bits 2;
       access rw;
       reset 2'h0;
    }
  }
  register HwtMRL_p1 @'h100020 {
    field HwtMRL_p1 @0 {
       bits 5;
       access rw;
       reset 5'h6;
    }
  }
  register DqsPreambleControl_p1 @'h100024 {
    field TwoTckRxDqsPre @0 {
       bits 1;
       access rw;
       reset 1'h0;
    }
    field TwoTckTxDqsPre @1 {
       bits 1;
       access rw;
       reset 1'h0;
    }
    field PositionDfeInit @2 {
       bits 3;
       access rw;
       reset 3'h2;
    }
    field LP4TglTwoTckTxDqsPre @5 {
       bits 1;
       access rw;
       reset 1'h0;
    }
    field LP4PostambleExt @6 {
       bits 1;
       access rw;
       reset 1'h0;
    }
    field LP4SttcPreBridgeRxEn @7 {
       bits 1;
       access rw;
       reset 1'h0;
    }
    field WDQSEXTENSION @8 {
       bits 1;
       access rw;
       reset 1'h0;
    }
  }
  register DMIPinPresent_p1 @'h10002d {
    field RdDbiEnabled @0 {
       bits 1;
       access rw;
       reset 1'h0;
    }
  }
  register ARdPtrInitVal_p1 @'h10002e {
    field ARdPtrInitVal_p1 @0 {
       bits 4;
       access rw;
       reset 4'h0;
    }
  }
  register ProcOdtTimeCtl_p1 @'h100056 {
    field POdtTailWidth @0 {
       bits 2;
       access rw;
       reset 2'h2;
    }
    field POdtStartDelay @2 {
       bits 2;
       access rw;
       reset 2'h1;
    }
    field POdtTailWidthExt @4 {
       bits 2;
       access rw;
       reset 2'h0;
    }
  }
  register DllGainCtl_p1 @'h10007c {
    field DllGainIV @0 {
       bits 4;
       access rw;
       reset 4'h1;
    }
    field DllGainTV @4 {
       bits 4;
       access rw;
       reset 4'ha;
    }
    field DllSeedSel @8 {
       bits 4;
       access rw;
       reset 4'h0;
    }
  }
  register DllLockParam_p1 @'h10007d {
    field RFU_DllLockParam_p1 @0 {
       bits 13;
       access rw;
       reset 13'h17c1;
    }
  }
  register DfiRdDataCsDestMap_p1 @'h1000b0 {
    field DfiRdDestm0 @0 {
       bits 2;
       access rw;
       reset 2'h0;
    }
    field DfiRdDestm1 @2 {
       bits 2;
       access rw;
       reset 2'h1;
    }
    field DfiRdDestm2 @4 {
       bits 2;
       access rw;
       reset 2'h2;
    }
    field DfiRdDestm3 @6 {
       bits 2;
       access rw;
       reset 2'h3;
    }
  }
  register VrefInGlobal_p1 @'h1000b2 {
    field GlobalVrefInSel @0 {
       bits 3;
       access rw;
       reset 3'h0;
    }
    field GlobalVrefInDAC @3 {
       bits 7;
       access rw;
       reset 7'h40;
    }
    field GlobalVrefInTrim @10 {
       bits 4;
       access rw;
       reset 4'h0;
    }
    field GlobalVrefInMode @14 {
       bits 1;
       access rw;
       reset 1'h0;
    }
  }
  register DfiWrDataCsDestMap_p1 @'h1000b4 {
    field DfiWrDestm0 @0 {
       bits 2;
       access rw;
       reset 2'h0;
    }
    field DfiWrDestm1 @2 {
       bits 2;
       access rw;
       reset 2'h1;
    }
    field DfiWrDestm2 @4 {
       bits 2;
       access rw;
       reset 2'h2;
    }
    field DfiWrDestm3 @6 {
       bits 2;
       access rw;
       reset 2'h3;
    }
  }
  register PllCtrl2_p1 @'h1000c5 {
    field PllFreqSel @0 {
       bits 5;
       access rw;
       reset 5'h19;
    }
  }
  register PllCtrl1_p1 @'h1000c7 {
    field PllCpIntCtrl @0 {
       bits 5;
       access rw;
       reset 5'h0;
    }
    field PllCpPropCtrl @5 {
       bits 4;
       access rw;
       reset 4'h1;
    }
  }
  register PllTestMode_p1 @'h1000ca {
    field PllTestMode_p1 @0 {
       bits 16;
       access rw;
       reset 16'h124;
    }
  }
  register PllCtrl4_p1 @'h1000cc {
    field PllCpIntGsCtrl @0 {
       bits 5;
       access rw;
       reset 5'h1f;
    }
    field PllCpPropGsCtrl @5 {
       bits 4;
       access rw;
       reset 4'hb;
    }
  }
  register DfiFreqRatio_p1 @'h1000fa {
    field DfiFreqRatio_p1 @0 {
       bits 2;
       access rw;
       reset 2'h1;
    }
  }
  register CalUclkInfo_p2 @'h200008 {
    field CalUClkTicksPer1uS @0 {
       bits 11;
       access rw;
       reset 11'h320;
    }
  }
  register Seq0BDLY0_p2 @'h20000b {
    field Seq0BDLY0_p2 @0 {
       bits 16;
       access rw;
       reset 16'h0;
    }
  }
  register Seq0BDLY1_p2 @'h20000c {
    field Seq0BDLY1_p2 @0 {
       bits 16;
       access rw;
       reset 16'h0;
    }
  }
  register Seq0BDLY2_p2 @'h20000d {
    field Seq0BDLY2_p2 @0 {
       bits 16;
       access rw;
       reset 16'h0;
    }
  }
  register Seq0BDLY3_p2 @'h20000e {
    field Seq0BDLY3_p2 @0 {
       bits 16;
       access rw;
       reset 16'h0;
    }
  }
  register PPTTrainSetup_p2 @'h200010 {
    field PhyMstrTrainInterval @0 {
       bits 4;
       access rw;
       reset 4'h0;
    }
    field PhyMstrMaxReqToAck @4 {
       bits 3;
       access rw;
       reset 3'h0;
    }
  }
  register PPTTrainSetup2_p2 @'h200011 {
    field RFU_PPTTrainSetup2_p2 @0 {
       bits 3;
       access rw;
       reset 3'h2;
    }
  }
  register TristateModeCA_p2 @'h200019 {
    field DisDynAdrTri @0 {
       bits 1;
       access rw;
       reset 1'h0;
    }
    field DDR2TMode @1 {
       bits 1;
       access rw;
       reset 1'h0;
    }
    field CkDisVal @2 {
       bits 2;
       access rw;
       reset 2'h0;
    }
  }
  register HwtMRL_p2 @'h200020 {
    field HwtMRL_p2 @0 {
       bits 5;
       access rw;
       reset 5'h6;
    }
  }
  register DqsPreambleControl_p2 @'h200024 {
    field TwoTckRxDqsPre @0 {
       bits 1;
       access rw;
       reset 1'h0;
    }
    field TwoTckTxDqsPre @1 {
       bits 1;
       access rw;
       reset 1'h0;
    }
    field PositionDfeInit @2 {
       bits 3;
       access rw;
       reset 3'h2;
    }
    field LP4TglTwoTckTxDqsPre @5 {
       bits 1;
       access rw;
       reset 1'h0;
    }
    field LP4PostambleExt @6 {
       bits 1;
       access rw;
       reset 1'h0;
    }
    field LP4SttcPreBridgeRxEn @7 {
       bits 1;
       access rw;
       reset 1'h0;
    }
    field WDQSEXTENSION @8 {
       bits 1;
       access rw;
       reset 1'h0;
    }
  }
  register DMIPinPresent_p2 @'h20002d {
    field RdDbiEnabled @0 {
       bits 1;
       access rw;
       reset 1'h0;
    }
  }
  register ARdPtrInitVal_p2 @'h20002e {
    field ARdPtrInitVal_p2 @0 {
       bits 4;
       access rw;
       reset 4'h0;
    }
  }
  register ProcOdtTimeCtl_p2 @'h200056 {
    field POdtTailWidth @0 {
       bits 2;
       access rw;
       reset 2'h2;
    }
    field POdtStartDelay @2 {
       bits 2;
       access rw;
       reset 2'h1;
    }
    field POdtTailWidthExt @4 {
       bits 2;
       access rw;
       reset 2'h0;
    }
  }
  register DllGainCtl_p2 @'h20007c {
    field DllGainIV @0 {
       bits 4;
       access rw;
       reset 4'h1;
    }
    field DllGainTV @4 {
       bits 4;
       access rw;
       reset 4'ha;
    }
    field DllSeedSel @8 {
       bits 4;
       access rw;
       reset 4'h0;
    }
  }
  register DllLockParam_p2 @'h20007d {
    field RFU_DllLockParam_p2 @0 {
       bits 13;
       access rw;
       reset 13'h17c1;
    }
  }
  register DfiRdDataCsDestMap_p2 @'h2000b0 {
    field DfiRdDestm0 @0 {
       bits 2;
       access rw;
       reset 2'h0;
    }
    field DfiRdDestm1 @2 {
       bits 2;
       access rw;
       reset 2'h1;
    }
    field DfiRdDestm2 @4 {
       bits 2;
       access rw;
       reset 2'h2;
    }
    field DfiRdDestm3 @6 {
       bits 2;
       access rw;
       reset 2'h3;
    }
  }
  register VrefInGlobal_p2 @'h2000b2 {
    field GlobalVrefInSel @0 {
       bits 3;
       access rw;
       reset 3'h0;
    }
    field GlobalVrefInDAC @3 {
       bits 7;
       access rw;
       reset 7'h40;
    }
    field GlobalVrefInTrim @10 {
       bits 4;
       access rw;
       reset 4'h0;
    }
    field GlobalVrefInMode @14 {
       bits 1;
       access rw;
       reset 1'h0;
    }
  }
  register DfiWrDataCsDestMap_p2 @'h2000b4 {
    field DfiWrDestm0 @0 {
       bits 2;
       access rw;
       reset 2'h0;
    }
    field DfiWrDestm1 @2 {
       bits 2;
       access rw;
       reset 2'h1;
    }
    field DfiWrDestm2 @4 {
       bits 2;
       access rw;
       reset 2'h2;
    }
    field DfiWrDestm3 @6 {
       bits 2;
       access rw;
       reset 2'h3;
    }
  }
  register PllCtrl2_p2 @'h2000c5 {
    field PllFreqSel @0 {
       bits 5;
       access rw;
       reset 5'h19;
    }
  }
  register PllCtrl1_p2 @'h2000c7 {
    field PllCpIntCtrl @0 {
       bits 5;
       access rw;
       reset 5'h0;
    }
    field PllCpPropCtrl @5 {
       bits 4;
       access rw;
       reset 4'h1;
    }
  }
  register PllTestMode_p2 @'h2000ca {
    field PllTestMode_p2 @0 {
       bits 16;
       access rw;
       reset 16'h124;
    }
  }
  register PllCtrl4_p2 @'h2000cc {
    field PllCpIntGsCtrl @0 {
       bits 5;
       access rw;
       reset 5'h1f;
    }
    field PllCpPropGsCtrl @5 {
       bits 4;
       access rw;
       reset 4'hb;
    }
  }
  register DfiFreqRatio_p2 @'h2000fa {
    field DfiFreqRatio_p2 @0 {
       bits 2;
       access rw;
       reset 2'h1;
    }
  }
  register CalUclkInfo_p3 @'h300008 {
    field CalUClkTicksPer1uS @0 {
       bits 11;
       access rw;
       reset 11'h320;
    }
  }
  register Seq0BDLY0_p3 @'h30000b {
    field Seq0BDLY0_p3 @0 {
       bits 16;
       access rw;
       reset 16'h0;
    }
  }
  register Seq0BDLY1_p3 @'h30000c {
    field Seq0BDLY1_p3 @0 {
       bits 16;
       access rw;
       reset 16'h0;
    }
  }
  register Seq0BDLY2_p3 @'h30000d {
    field Seq0BDLY2_p3 @0 {
       bits 16;
       access rw;
       reset 16'h0;
    }
  }
  register Seq0BDLY3_p3 @'h30000e {
    field Seq0BDLY3_p3 @0 {
       bits 16;
       access rw;
       reset 16'h0;
    }
  }
  register PPTTrainSetup_p3 @'h300010 {
    field PhyMstrTrainInterval @0 {
       bits 4;
       access rw;
       reset 4'h0;
    }
    field PhyMstrMaxReqToAck @4 {
       bits 3;
       access rw;
       reset 3'h0;
    }
  }
  register PPTTrainSetup2_p3 @'h300011 {
    field RFU_PPTTrainSetup2_p3 @0 {
       bits 3;
       access rw;
       reset 3'h2;
    }
  }
  register TristateModeCA_p3 @'h300019 {
    field DisDynAdrTri @0 {
       bits 1;
       access rw;
       reset 1'h0;
    }
    field DDR2TMode @1 {
       bits 1;
       access rw;
       reset 1'h0;
    }
    field CkDisVal @2 {
       bits 2;
       access rw;
       reset 2'h0;
    }
  }
  register HwtMRL_p3 @'h300020 {
    field HwtMRL_p3 @0 {
       bits 5;
       access rw;
       reset 5'h6;
    }
  }
  register DqsPreambleControl_p3 @'h300024 {
    field TwoTckRxDqsPre @0 {
       bits 1;
       access rw;
       reset 1'h0;
    }
    field TwoTckTxDqsPre @1 {
       bits 1;
       access rw;
       reset 1'h0;
    }
    field PositionDfeInit @2 {
       bits 3;
       access rw;
       reset 3'h2;
    }
    field LP4TglTwoTckTxDqsPre @5 {
       bits 1;
       access rw;
       reset 1'h0;
    }
    field LP4PostambleExt @6 {
       bits 1;
       access rw;
       reset 1'h0;
    }
    field LP4SttcPreBridgeRxEn @7 {
       bits 1;
       access rw;
       reset 1'h0;
    }
    field WDQSEXTENSION @8 {
       bits 1;
       access rw;
       reset 1'h0;
    }
  }
  register DMIPinPresent_p3 @'h30002d {
    field RdDbiEnabled @0 {
       bits 1;
       access rw;
       reset 1'h0;
    }
  }
  register ARdPtrInitVal_p3 @'h30002e {
    field ARdPtrInitVal_p3 @0 {
       bits 4;
       access rw;
       reset 4'h0;
    }
  }
  register ProcOdtTimeCtl_p3 @'h300056 {
    field POdtTailWidth @0 {
       bits 2;
       access rw;
       reset 2'h2;
    }
    field POdtStartDelay @2 {
       bits 2;
       access rw;
       reset 2'h1;
    }
    field POdtTailWidthExt @4 {
       bits 2;
       access rw;
       reset 2'h0;
    }
  }
  register DllGainCtl_p3 @'h30007c {
    field DllGainIV @0 {
       bits 4;
       access rw;
       reset 4'h1;
    }
    field DllGainTV @4 {
       bits 4;
       access rw;
       reset 4'ha;
    }
    field DllSeedSel @8 {
       bits 4;
       access rw;
       reset 4'h0;
    }
  }
  register DllLockParam_p3 @'h30007d {
    field RFU_DllLockParam_p3 @0 {
       bits 13;
       access rw;
       reset 13'h17c1;
    }
  }
  register DfiRdDataCsDestMap_p3 @'h3000b0 {
    field DfiRdDestm0 @0 {
       bits 2;
       access rw;
       reset 2'h0;
    }
    field DfiRdDestm1 @2 {
       bits 2;
       access rw;
       reset 2'h1;
    }
    field DfiRdDestm2 @4 {
       bits 2;
       access rw;
       reset 2'h2;
    }
    field DfiRdDestm3 @6 {
       bits 2;
       access rw;
       reset 2'h3;
    }
  }
  register VrefInGlobal_p3 @'h3000b2 {
    field GlobalVrefInSel @0 {
       bits 3;
       access rw;
       reset 3'h0;
    }
    field GlobalVrefInDAC @3 {
       bits 7;
       access rw;
       reset 7'h40;
    }
    field GlobalVrefInTrim @10 {
       bits 4;
       access rw;
       reset 4'h0;
    }
    field GlobalVrefInMode @14 {
       bits 1;
       access rw;
       reset 1'h0;
    }
  }
  register DfiWrDataCsDestMap_p3 @'h3000b4 {
    field DfiWrDestm0 @0 {
       bits 2;
       access rw;
       reset 2'h0;
    }
    field DfiWrDestm1 @2 {
       bits 2;
       access rw;
       reset 2'h1;
    }
    field DfiWrDestm2 @4 {
       bits 2;
       access rw;
       reset 2'h2;
    }
    field DfiWrDestm3 @6 {
       bits 2;
       access rw;
       reset 2'h3;
    }
  }
  register PllCtrl2_p3 @'h3000c5 {
    field PllFreqSel @0 {
       bits 5;
       access rw;
       reset 5'h19;
    }
  }
  register PllCtrl1_p3 @'h3000c7 {
    field PllCpIntCtrl @0 {
       bits 5;
       access rw;
       reset 5'h0;
    }
    field PllCpPropCtrl @5 {
       bits 4;
       access rw;
       reset 4'h1;
    }
  }
  register PllTestMode_p3 @'h3000ca {
    field PllTestMode_p3 @0 {
       bits 16;
       access rw;
       reset 16'h124;
    }
  }
  register PllCtrl4_p3 @'h3000cc {
    field PllCpIntGsCtrl @0 {
       bits 5;
       access rw;
       reset 5'h1f;
    }
    field PllCpPropGsCtrl @5 {
       bits 4;
       access rw;
       reset 4'hb;
    }
  }
  register DfiFreqRatio_p3 @'h3000fa {
    field DfiFreqRatio_p3 @0 {
       bits 2;
       access rw;
       reset 2'h1;
    }
  }
}
block dwc_ddrphy_top_DWC_DDRPHYA_PPGC0 {
  endian little;
  bytes 2;
  register PPGCCtrl1 @'h11 {
    field Reserved_0_0 @0 {
       bits 1;
       access ro;
       attributes {NO_REG_TESTS 1}
    }
    field RFU_PPGCCtrl1 @1 {
       bits 4;
       access rw;
       reset 4'h0;
    }
  }
  register PpgcLane2CrcInMap0 @'h15 {
    field RFU_PpgcLane2CrcInMap0 @0 {
       bits 12;
       access rw;
       reset 12'h0;
    }
  }
  register PpgcLane2CrcInMap1 @'h16 {
    field RFU_PpgcLane2CrcInMap1 @0 {
       bits 12;
       access rw;
       reset 12'h0;
    }
  }
  register PrbsTapDly0_i0 @'h24 {
    field PrbsTapDly0_i0 @0 {
       bits 16;
       access rw;
       reset 16'h0;
    }
  }
  register PrbsTapDly1_i0 @'h25 {
    field PrbsTapDly1_i0 @0 {
       bits 16;
       access rw;
       reset 16'h0;
    }
  }
  register PrbsTapDly2_i0 @'h26 {
    field PrbsTapDly2_i0 @0 {
       bits 16;
       access rw;
       reset 16'h0;
    }
  }
  register PrbsTapDly3_i0 @'h27 {
    field PrbsTapDly3_i0 @0 {
       bits 16;
       access rw;
       reset 16'h0;
    }
  }
  register GenPrbsByte0 @'h30 {
    field GenPrbsByte0 @0 {
       bits 16;
       access rw;
       reset 16'h0;
    }
  }
  register GenPrbsByte1 @'h31 {
    field GenPrbsByte1 @0 {
       bits 16;
       access rw;
       reset 16'h0;
    }
  }
  register GenPrbsByte2 @'h32 {
    field GenPrbsByte2 @0 {
       bits 16;
       access rw;
       reset 16'h0;
    }
  }
  register GenPrbsByte3 @'h33 {
    field GenPrbsByte3 @0 {
       bits 16;
       access rw;
       reset 16'h0;
    }
  }
  register GenPrbsByte4 @'h34 {
    field GenPrbsByte4 @0 {
       bits 16;
       access rw;
       reset 16'h0;
    }
  }
  register GenPrbsByte5 @'h35 {
    field GenPrbsByte5 @0 {
       bits 16;
       access rw;
       reset 16'h0;
    }
  }
  register GenPrbsByte6 @'h36 {
    field GenPrbsByte6 @0 {
       bits 16;
       access rw;
       reset 16'h0;
    }
  }
  register GenPrbsByte7 @'h37 {
    field GenPrbsByte7 @0 {
       bits 16;
       access rw;
       reset 16'h0;
    }
  }
  register GenPrbsByte8 @'h38 {
    field GenPrbsByte8 @0 {
       bits 16;
       access rw;
       reset 16'h0;
    }
  }
  register GenPrbsByte9 @'h39 {
    field GenPrbsByte9 @0 {
       bits 16;
       access rw;
       reset 16'h0;
    }
  }
  register GenPrbsByte10 @'h3a {
    field GenPrbsByte10 @0 {
       bits 16;
       access rw;
       reset 16'h0;
    }
  }
  register GenPrbsByte11 @'h3b {
    field GenPrbsByte11 @0 {
       bits 16;
       access rw;
       reset 16'h0;
    }
  }
  register GenPrbsByte12 @'h3c {
    field GenPrbsByte12 @0 {
       bits 16;
       access rw;
       reset 16'h0;
    }
  }
  register GenPrbsByte13 @'h3d {
    field GenPrbsByte13 @0 {
       bits 16;
       access rw;
       reset 16'h0;
    }
  }
  register GenPrbsByte14 @'h3e {
    field GenPrbsByte14 @0 {
       bits 16;
       access rw;
       reset 16'h0;
    }
  }
  register GenPrbsByte15 @'h3f {
    field GenPrbsByte15 @0 {
       bits 16;
       access rw;
       reset 16'h0;
    }
  }
  register PrbsGenCtl @'h60 {
    field RFU_PrbsGenCtl @0 {
       bits 7;
       access rw;
       reset 7'h0;
    }
  }
  register PrbsGenStateLo @'h61 {
    field PrbsGenStateLo @0 {
       bits 16;
       access rw;
       reset 16'h0;
    }
  }
  register PrbsGenStateHi @'h62 {
    field PrbsGenStateHi @0 {
       bits 7;
       access rw;
       reset 7'h0;
    }
  }
  register PrbsChkStateLo @'h63 {
    field PrbsChkStateLo @0 {
       bits 16;
       access rw;
       reset 16'h0;
    }
  }
  register PrbsChkStateHi @'h64 {
    field PrbsChkStateHi @0 {
       bits 7;
       access rw;
       reset 7'h0;
    }
  }
  register PrbsGenCtl1 @'h65 {
    field RFU_PrbsGenCtl1 @0 {
       bits 9;
       access rw;
       reset 9'h0;
    }
  }
  register PrbsGenCtl2 @'h66 {
    field RFU_PrbsGenCtl2 @0 {
       bits 16;
       access rw;
       reset 16'h0;
    }
  }
  register PrbsTapDly0_i1 @'h124 {
    field PrbsTapDly0_i1 @0 {
       bits 16;
       access rw;
       reset 16'h0;
    }
  }
  register PrbsTapDly1_i1 @'h125 {
    field PrbsTapDly1_i1 @0 {
       bits 16;
       access rw;
       reset 16'h0;
    }
  }
  register PrbsTapDly2_i1 @'h126 {
    field PrbsTapDly2_i1 @0 {
       bits 16;
       access rw;
       reset 16'h0;
    }
  }
  register PrbsTapDly3_i1 @'h127 {
    field PrbsTapDly3_i1 @0 {
       bits 16;
       access rw;
       reset 16'h0;
    }
  }
  register PrbsTapDly0_i2 @'h224 {
    field PrbsTapDly0_i2 @0 {
       bits 16;
       access rw;
       reset 16'h0;
    }
  }
  register PrbsTapDly1_i2 @'h225 {
    field PrbsTapDly1_i2 @0 {
       bits 16;
       access rw;
       reset 16'h0;
    }
  }
  register PrbsTapDly2_i2 @'h226 {
    field PrbsTapDly2_i2 @0 {
       bits 16;
       access rw;
       reset 16'h0;
    }
  }
  register PrbsTapDly3_i2 @'h227 {
    field PrbsTapDly3_i2 @0 {
       bits 16;
       access rw;
       reset 16'h0;
    }
  }
  register PrbsTapDly0_i3 @'h324 {
    field PrbsTapDly0_i3 @0 {
       bits 16;
       access rw;
       reset 16'h0;
    }
  }
  register PrbsTapDly1_i3 @'h325 {
    field PrbsTapDly1_i3 @0 {
       bits 16;
       access rw;
       reset 16'h0;
    }
  }
  register PrbsTapDly2_i3 @'h326 {
    field PrbsTapDly2_i3 @0 {
       bits 16;
       access rw;
       reset 16'h0;
    }
  }
  register PrbsTapDly3_i3 @'h327 {
    field PrbsTapDly3_i3 @0 {
       bits 16;
       access rw;
       reset 16'h0;
    }
  }
  register PrbsTapDly0_i4 @'h424 {
    field PrbsTapDly0_i4 @0 {
       bits 16;
       access rw;
       reset 16'h0;
    }
  }
  register PrbsTapDly1_i4 @'h425 {
    field PrbsTapDly1_i4 @0 {
       bits 16;
       access rw;
       reset 16'h0;
    }
  }
  register PrbsTapDly2_i4 @'h426 {
    field PrbsTapDly2_i4 @0 {
       bits 16;
       access rw;
       reset 16'h0;
    }
  }
  register PrbsTapDly3_i4 @'h427 {
    field PrbsTapDly3_i4 @0 {
       bits 16;
       access rw;
       reset 16'h0;
    }
  }
  register PrbsTapDly0_i5 @'h524 {
    field PrbsTapDly0_i5 @0 {
       bits 16;
       access rw;
       reset 16'h0;
    }
  }
  register PrbsTapDly1_i5 @'h525 {
    field PrbsTapDly1_i5 @0 {
       bits 16;
       access rw;
       reset 16'h0;
    }
  }
  register PrbsTapDly2_i5 @'h526 {
    field PrbsTapDly2_i5 @0 {
       bits 16;
       access rw;
       reset 16'h0;
    }
  }
  register PrbsTapDly3_i5 @'h527 {
    field PrbsTapDly3_i5 @0 {
       bits 16;
       access rw;
       reset 16'h0;
    }
  }
  register PrbsTapDly0_i6 @'h624 {
    field PrbsTapDly0_i6 @0 {
       bits 16;
       access rw;
       reset 16'h0;
    }
  }
  register PrbsTapDly1_i6 @'h625 {
    field PrbsTapDly1_i6 @0 {
       bits 16;
       access rw;
       reset 16'h0;
    }
  }
  register PrbsTapDly2_i6 @'h626 {
    field PrbsTapDly2_i6 @0 {
       bits 16;
       access rw;
       reset 16'h0;
    }
  }
  register PrbsTapDly3_i6 @'h627 {
    field PrbsTapDly3_i6 @0 {
       bits 16;
       access rw;
       reset 16'h0;
    }
  }
  register PrbsTapDly0_i7 @'h724 {
    field PrbsTapDly0_i7 @0 {
       bits 16;
       access rw;
       reset 16'h0;
    }
  }
  register PrbsTapDly1_i7 @'h725 {
    field PrbsTapDly1_i7 @0 {
       bits 16;
       access rw;
       reset 16'h0;
    }
  }
  register PrbsTapDly2_i7 @'h726 {
    field PrbsTapDly2_i7 @0 {
       bits 16;
       access rw;
       reset 16'h0;
    }
  }
  register PrbsTapDly3_i7 @'h727 {
    field PrbsTapDly3_i7 @0 {
       bits 16;
       access rw;
       reset 16'h0;
    }
  }
  register PrbsTapDly0_i8 @'h824 {
    field PrbsTapDly0_i8 @0 {
       bits 16;
       access rw;
       reset 16'h0;
    }
  }
  register PrbsTapDly1_i8 @'h825 {
    field PrbsTapDly1_i8 @0 {
       bits 16;
       access rw;
       reset 16'h0;
    }
  }
  register PrbsTapDly2_i8 @'h826 {
    field PrbsTapDly2_i8 @0 {
       bits 16;
       access rw;
       reset 16'h0;
    }
  }
  register PrbsTapDly3_i8 @'h827 {
    field PrbsTapDly3_i8 @0 {
       bits 16;
       access rw;
       reset 16'h0;
    }
  }
}


system dwc_ddrphy_top {
  bytes 2;
  block dwc_ddrphy_top_DWC_DDRPHYA_ACSM0 @'h40000;
  block dwc_ddrphy_top_DWC_DDRPHYA_ANIB0 @'h0;
  block dwc_ddrphy_top_DWC_DDRPHYA_ANIB1 @'h1000;
  block dwc_ddrphy_top_DWC_DDRPHYA_ANIB2 @'h2000;
  block dwc_ddrphy_top_DWC_DDRPHYA_ANIB3 @'h3000;
  block dwc_ddrphy_top_DWC_DDRPHYA_ANIB4 @'h4000;
  block dwc_ddrphy_top_DWC_DDRPHYA_ANIB5 @'h5000;
  block dwc_ddrphy_top_DWC_DDRPHYA_ANIB6 @'h6000;
  block dwc_ddrphy_top_DWC_DDRPHYA_ANIB7 @'h7000;
  block dwc_ddrphy_top_DWC_DDRPHYA_ANIB8 @'h8000;
  block dwc_ddrphy_top_DWC_DDRPHYA_ANIB9 @'h9000;
  block dwc_ddrphy_top_DWC_DDRPHYA_ANIB10 @'ha000;
  block dwc_ddrphy_top_DWC_DDRPHYA_ANIB11 @'hb000;
  block dwc_ddrphy_top_DWC_DDRPHYA_APBONLY0 @'hd0000;
  block dwc_ddrphy_top_DWC_DDRPHYA_DBYTE0 @'h10000;
  block dwc_ddrphy_top_DWC_DDRPHYA_DBYTE1 @'h11000;
  block dwc_ddrphy_top_DWC_DDRPHYA_DBYTE2 @'h12000;
  block dwc_ddrphy_top_DWC_DDRPHYA_DBYTE3 @'h13000;
  block dwc_ddrphy_top_DWC_DDRPHYA_DBYTE4 @'h14000;
  block dwc_ddrphy_top_DWC_DDRPHYA_DBYTE5 @'h15000;
  block dwc_ddrphy_top_DWC_DDRPHYA_DBYTE6 @'h16000;
  block dwc_ddrphy_top_DWC_DDRPHYA_DBYTE7 @'h17000;
  block dwc_ddrphy_top_DWC_DDRPHYA_DBYTE8 @'h18000;
  block dwc_ddrphy_top_DWC_DDRPHYA_DBYTE9 @'h19000;
  block dwc_ddrphy_top_DWC_DDRPHYA_DRTUB0 @'hc0000;
  block dwc_ddrphy_top_DWC_DDRPHYA_INITENG0 @'h90000;
  block dwc_ddrphy_top_DWC_DDRPHYA_MASTER0 @'h20000;
  block dwc_ddrphy_top_DWC_DDRPHYA_PPGC0 @'h70000;
}

